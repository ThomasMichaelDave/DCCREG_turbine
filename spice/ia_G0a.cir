* ISLAND-ASDRAWN deck G0a: lx=0.0 cx=big bracket=a stray_ref=5.0pF motor=False tank=collapsed gap=ideal
* generated by sim/island_asdrawn.py from topology_edge_list.csv (node-exact).
.include timing_asdrawn.sub
.include sparkgap_bidir.sub
Xclk arm_sg1 arm_sg3a1 arm_sg3b1 arm_bs3 arm_sg2 arm_sg4a1 arm_sg4b1 arm_bs4 timing_asdrawn
C_BS3_stray 7 3 2.000000e-12
C_BS4_stray 8 2 2.000000e-12
C_Ca1 1 2 3.090000e-10
C_Cb1 3 4 3.090000e-10
C_Cx3 7 n17 1.000000e-07
C_Cx3_boss 7 n17 1.200000e-11
C_Cx4 n23 8 1.000000e-07
C_Cx4_boss n23 8 1.200000e-11
C_SG1_stray 2 0 2.000000e-12
C_SG2_stray 3 0 2.000000e-12
C_SG3a1_stray 1 7 2.000000e-12
C_SG3b1_stray 7 3 2.000000e-12
C_SG4a1_stray 4 8 2.000000e-12
C_SG4b1_stray 8 2 2.000000e-12
C_Cpar1 1 0 2.000000e-11
C_Cpar2 2 0 2.000000e-11
C_Cpar3 3 0 2.000000e-11
C_Cpar4 4 0 2.000000e-11
C_Cs_7 7 0 5.000000e-12
C_Cs_8 8 0 5.000000e-12
C_Cs_n17 n17 0 5.000000e-12
C_Cs_n23 n23 0 5.000000e-12
V_C1i 1 x_c1 0
F_C1q 0 q_c1 V_C1i 1
C_C1q q_c1 0 1.0e-09
B_C1v x_c1 0 V='V(q_c1)*1.0e-09/(1.6000e-11+2.6400e-10*(0.5*(1+tanh(12.0*sin(1.884955592e+03*time+0.000000000)))))'
V_C2i 4 x_c2 0
F_C2q 0 q_c2 V_C2i 1
C_C2q q_c2 0 1.0e-09
B_C2v x_c2 0 V='V(q_c2)*1.0e-09/(1.6000e-11+2.6400e-10*(0.5*(1+tanh(12.0*sin(1.884955592e+03*time+3.141592654)))))'
V_Lx3 n17 3 0
V_Lx4 2 n23 0
V_sBS3 7 s_bs3 0
XBS3 s_bs3 3 arm_bs3 sparkgap_bidir
V_sBS4 8 s_bs4 0
XBS4 s_bs4 2 arm_bs4 sparkgap_bidir
V_sSG1 2 s_sg1 0
XSG1 s_sg1 0 arm_sg1 gap_oneway
V_sSG2 3 s_sg2 0
XSG2 s_sg2 0 arm_sg2 gap_oneway
V_sSG3a1 1 s_sg3a1 0
XSG3a1 s_sg3a1 7 arm_sg3a1 gap_oneway
V_sSG3b1 7 s_sg3b1 0
XSG3b1 s_sg3b1 3 arm_sg3b1 sparkgap_bidir
V_sSG4a1 4 s_sg4a1 0
XSG4a1 s_sg4a1 8 arm_sg4a1 gap_oneway
V_sSG4b1 8 s_sg4b1 0
XSG4b1 s_sg4b1 2 arm_sg4b1 sparkgap_bidir
.ic v(1)=-100.0 v(2)=0.0 v(3)=0.0 v(4)=-100.0 v(7)=0.0 v(8)=0.0 v(n17)=0.0 v(n23)=0.0 v(q_c1)=-14.8 v(q_c2)=-14.8
.control
set filetype=binary
tran 1.00e-06 4.333333e-02 uic
write ia_raw/G0a.raw v(1) v(2) v(3) v(4) v(7) v(8) v(n17) v(n23) i(v_sbs3) i(v_sbs4) i(v_ssg1) i(v_ssg2) i(v_ssg3a1) i(v_ssg3b1) i(v_ssg4a1) i(v_ssg4b1) i(v_lx3) i(v_lx4)
.endc
.options reltol=1e-04 abstol=1e-9 vntol=1e-9 gmin=1e-14 maxstep=1.00e-06 method=trap itl4=200
.end
