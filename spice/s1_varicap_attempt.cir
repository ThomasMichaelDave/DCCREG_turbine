* S1 varicap const-Q stroke via C(t)+Bwork (the converging approximation; ideal ratio 2.0)
.param Chi=2n Clo=1n tr0=2u tr1=3u dCdt=-1m
Cv 1 0 C='Chi + (Clo-Chi)*limit((time-tr0)/(tr1-tr0),0,1)'
Vdcdt dc 0 PWL(0 0 1.999u 0 2u {dCdt} 3u {dCdt} 3.001u 0)
Bwork 1 0 I='v(1)*v(dc)'
Iseed 0 1 PWL(0 0 10n 2 1u 2 1.01u 0)
.control
tran 1n 4u uic
meas tran vc FIND v(1) AT=1.5u
meas tran vf FIND v(1) AT=3.5u
.endc
.end
