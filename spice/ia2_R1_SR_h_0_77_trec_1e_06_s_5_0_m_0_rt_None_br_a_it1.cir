* ISLAND-ASDRAWN deck ia2_R1_SR_h_0_77_trec_1e_06_s_5_0_m_0_rt_None_br_a_it1: lx=0.001 cx=profile bracket=a stray_ref=5.0pF motor=False tank=collapsed gap=ideal
* generated by sim/island_asdrawn.py from topology_edge_list.csv (node-exact).
.include timing_asdrawn.sub
.include sparkgap_bidir.sub
.include ia2_gap.sub
Xclk arm_sg1 arm_sg3a1 arm_sg3b1 arm_bs3 arm_sg2 arm_sg4a1 arm_sg4b1 arm_bs4 timing_asdrawn
C_BS3_stray 7 3 2.000000e-12
C_BS4_stray 8 2 2.000000e-12
C_Ca1 1 2 3.090000e-10
C_Cb1 3 4 3.090000e-10
C_Cx3_boss 7 n17 1.200000e-11
C_Cx4_boss n23 8 1.200000e-11
C_SG1_stray 2 0 2.000000e-12
C_SG2_stray 3 0 2.000000e-12
C_SG3a1_stray 1 7 2.000000e-12
C_SG3b1_stray 7 3 2.000000e-12
C_SG4a1_stray 4 8 2.000000e-12
C_SG4b1_stray 8 2 2.000000e-12
C_Cpar1 1 0 2.000000e-11
C_Cpar2 2 0 2.000000e-11
C_Cpar3 3 0 2.000000e-11
C_Cpar4 4 0 2.000000e-11
C_Cs_7 7 0 5.000000e-12
C_Cs_8 8 0 5.000000e-12
C_Cs_n17 n17 0 5.000000e-12
C_Cs_n23 n23 0 5.000000e-12
V_C1i 1 x_c1 0
F_C1q 0 q_c1 V_C1i 1
C_C1q q_c1 0 1.0e-09
B_C1v x_c1 0 V='V(q_c1)*1.0e-09/(1.6000e-11+2.6400e-10*(0.5*(1+tanh(12.0*sin(1.884955592e+03*time+0.000000000)))))'
V_C2i 4 x_c2 0
F_C2q 0 q_c2 V_C2i 1
C_C2q q_c2 0 1.0e-09
B_C2v x_c2 0 V='V(q_c2)*1.0e-09/(1.6000e-11+2.6400e-10*(0.5*(1+tanh(12.0*sin(1.884955592e+03*time+3.141592654)))))'
V_Cx3c cx3c 0 PWL(0.000000000e+00 471 5.555555556e-06 471 1.111111111e-05 471 1.666666667e-05 471 2.222222222e-05 471 2.777777778e-05 471 3.333333333e-05 471 3.888888889e-05 471 4.444444444e-05 471 5.000000000e-05 471 5.555555556e-05 471 6.111111111e-05 471 6.666666667e-05 471 7.222222222e-05 471 7.777777778e-05 471 8.333333333e-05 471 8.888888889e-05 471 9.444444444e-05 471 1.000000000e-04 471 1.055555556e-04 471 1.111111111e-04 471 1.166666667e-04 471 1.222222222e-04 471 1.277777778e-04 471 1.333333333e-04 471 1.388888889e-04 471 1.444444444e-04 471 1.500000000e-04 471 1.555555556e-04 471 1.611111111e-04 471 1.666666667e-04 471 1.722222222e-04 471 1.777777778e-04 471 1.833333333e-04 471 1.888888889e-04 471 1.944444444e-04 471 2.000000000e-04 471 2.055555556e-04 471 2.111111111e-04 471 2.166666667e-04 471 2.222222222e-04 471 2.277777778e-04 471 2.333333333e-04 471 2.388888889e-04 471 2.444444444e-04 471 2.500000000e-04 471 2.555555556e-04 471 2.611111111e-04 471 2.666666667e-04 471 2.722222222e-04 471 2.777777778e-04 471 2.833333333e-04 471 2.888888889e-04 471 2.944444444e-04 471 3.000000000e-04 471 3.055555556e-04 471 3.111111111e-04 471 3.166666667e-04 471 3.222222222e-04 471 3.277777778e-04 471 3.333333333e-04 471 3.388888889e-04 471 3.444444444e-04 471 3.500000000e-04 471 3.555555556e-04 471 3.611111111e-04 471 3.666666667e-04 471 3.722222222e-04 471 3.777777778e-04 471 3.833333333e-04 471 3.888888889e-04 471 3.944444444e-04 471 4.000000000e-04 471 4.055555556e-04 471 4.111111111e-04 471 4.166666667e-04 471 4.222222222e-04 471 4.277777778e-04 471 4.333333333e-04 471 4.388888889e-04 471 4.444444444e-04 471 4.500000000e-04 471 4.555555556e-04 471 4.611111111e-04 471 4.666666667e-04 471 4.722222222e-04 471 4.777777778e-04 471 4.833333333e-04 471 4.888888889e-04 471 4.944444444e-04 471 5.000000000e-04 471 5.055555556e-04 471 5.111111111e-04 471 5.166666667e-04 471 5.222222222e-04 471 5.277777778e-04 471 5.333333333e-04 471 5.388888889e-04 471 5.444444444e-04 471 5.500000000e-04 471 5.555555556e-04 471 5.611111111e-04 471 5.666666667e-04 471 5.722222222e-04 471 5.777777778e-04 471 5.833333333e-04 471 5.888888889e-04 471 5.944444444e-04 471 6.000000000e-04 471 6.055555556e-04 471 6.111111111e-04 471 6.166666667e-04 471 6.222222222e-04 471 6.277777778e-04 471 6.333333333e-04 471 6.388888889e-04 471 6.444444444e-04 471 6.500000000e-04 471 6.555555556e-04 471 6.611111111e-04 471 6.666666667e-04 471 6.722222222e-04 471 6.777777778e-04 471 6.833333333e-04 471 6.888888889e-04 471 6.944444444e-04 471 7.000000000e-04 471 7.055555556e-04 471 7.111111111e-04 471 7.166666667e-04 471 7.222222222e-04 471 7.277777778e-04 471 7.333333333e-04 471 7.388888889e-04 471 7.444444444e-04 471 7.500000000e-04 471 7.555555556e-04 471 7.611111111e-04 471 7.666666667e-04 471 7.722222222e-04 471 7.777777778e-04 471 7.833333333e-04 471 7.888888889e-04 471 7.944444444e-04 471 8.000000000e-04 471 8.055555556e-04 471 8.111111111e-04 471 8.166666667e-04 471 8.222222222e-04 471 8.277777778e-04 471 8.333333333e-04 471 8.388888889e-04 471 8.444444444e-04 471 8.500000000e-04 471 8.555555556e-04 471 8.611111111e-04 471 8.666666667e-04 471 8.722222222e-04 470.913 8.777777778e-04 470.652 8.833333333e-04 470.218 8.888888889e-04 469.61 8.944444444e-04 468.83 9.000000000e-04 467.878 9.055555556e-04 466.754 9.111111111e-04 465.461 9.166666667e-04 463.998 9.222222222e-04 462.367 9.277777778e-04 460.569 9.333333333e-04 458.607 9.388888889e-04 456.481 9.444444444e-04 454.193 9.500000000e-04 451.746 9.555555556e-04 449.142 9.611111111e-04 446.381 9.666666667e-04 443.468 9.722222222e-04 440.404 9.777777778e-04 437.193 9.833333333e-04 433.836 9.888888889e-04 430.336 9.944444444e-04 426.697 1.000000000e-03 422.922 1.005555556e-03 419.014 1.011111111e-03 414.975 1.016666667e-03 410.81 1.022222222e-03 406.523 1.027777778e-03 402.116 1.033333333e-03 397.593 1.038888889e-03 392.958 1.044444444e-03 388.216 1.050000000e-03 383.37 1.055555556e-03 378.424 1.061111111e-03 373.383 1.066666667e-03 368.25 1.072222222e-03 363.03 1.077777778e-03 357.728 1.083333333e-03 352.348 1.088888889e-03 346.894 1.094444444e-03 341.372 1.100000000e-03 335.785 1.105555556e-03 330.139 1.111111111e-03 324.438 1.116666667e-03 318.687 1.122222222e-03 312.892 1.127777778e-03 307.056 1.133333333e-03 301.185 1.138888889e-03 295.283 1.144444444e-03 289.357 1.150000000e-03 283.411 1.155555556e-03 277.449 1.161111111e-03 271.477 1.166666667e-03 265.5 1.172222222e-03 259.523 1.177777778e-03 253.551 1.183333333e-03 247.589 1.188888889e-03 241.643 1.194444444e-03 235.717 1.200000000e-03 229.815 1.205555556e-03 223.944 1.211111111e-03 218.108 1.216666667e-03 212.313 1.222222222e-03 206.562 1.227777778e-03 200.861 1.233333333e-03 195.215 1.238888889e-03 189.628 1.244444444e-03 184.106 1.250000000e-03 178.652 1.255555556e-03 173.272 1.261111111e-03 167.97 1.266666667e-03 162.75 1.272222222e-03 157.617 1.277777778e-03 152.576 1.283333333e-03 147.63 1.288888889e-03 142.784 1.294444444e-03 138.042 1.300000000e-03 133.407 1.305555556e-03 128.884 1.311111111e-03 124.477 1.316666667e-03 120.19 1.322222222e-03 116.025 1.327777778e-03 111.986 1.333333333e-03 108.078 1.338888889e-03 104.303 1.344444444e-03 100.664 1.350000000e-03 97.1643 1.355555556e-03 93.8073 1.361111111e-03 90.5955 1.366666667e-03 87.5318 1.372222222e-03 84.6186 1.377777778e-03 81.8585 1.383333333e-03 79.2537 1.388888889e-03 76.8066 1.394444444e-03 74.5191 1.400000000e-03 72.3932 1.405555556e-03 70.4306 1.411111111e-03 68.6332 1.416666667e-03 67.0022 1.422222222e-03 65.5393 1.427777778e-03 64.2455 1.433333333e-03 63.122 1.438888889e-03 62.1697 1.444444444e-03 61.3895 1.450000000e-03 60.782 1.455555556e-03 60.3477 1.461111111e-03 60.0869 1.466666667e-03 60 1.472222222e-03 60 1.477777778e-03 60 1.483333333e-03 60 1.488888889e-03 60 1.494444444e-03 60 1.500000000e-03 60 1.505555556e-03 60 1.511111111e-03 60 1.516666667e-03 60 1.522222222e-03 60 1.527777778e-03 60 1.533333333e-03 60 1.538888889e-03 60 1.544444444e-03 60 1.550000000e-03 60 1.555555556e-03 60 1.561111111e-03 60 1.566666667e-03 60 1.572222222e-03 60 1.577777778e-03 60 1.583333333e-03 60 1.588888889e-03 60 1.594444444e-03 60 1.600000000e-03 60 1.605555556e-03 60 1.611111111e-03 60 1.616666667e-03 60 1.622222222e-03 60 1.627777778e-03 60 1.633333333e-03 60 1.638888889e-03 60 1.644444444e-03 60 1.650000000e-03 60 1.655555556e-03 60 1.661111111e-03 60 1.666666667e-03 60 1.672222222e-03 60 1.677777778e-03 60 1.683333333e-03 60 1.688888889e-03 60 1.694444444e-03 60 1.700000000e-03 60 1.705555556e-03 60 1.711111111e-03 60 1.716666667e-03 60 1.722222222e-03 60 1.727777778e-03 60 1.733333333e-03 60 1.738888889e-03 60 1.744444444e-03 60 1.750000000e-03 60 1.755555556e-03 60 1.761111111e-03 60 1.766666667e-03 60 1.772222222e-03 60 1.777777778e-03 60 1.783333333e-03 60 1.788888889e-03 60 1.794444444e-03 60 1.800000000e-03 60 1.805555556e-03 60 1.811111111e-03 60 1.816666667e-03 60 1.822222222e-03 60 1.827777778e-03 60 1.833333333e-03 60 1.838888889e-03 60 1.844444444e-03 60 1.850000000e-03 60 1.855555556e-03 60 1.861111111e-03 60 1.866666667e-03 60 1.872222222e-03 60 1.877777778e-03 60 1.883333333e-03 60 1.888888889e-03 60 1.894444444e-03 60 1.900000000e-03 60 1.905555556e-03 60 1.911111111e-03 60 1.916666667e-03 60 1.922222222e-03 60 1.927777778e-03 60 1.933333333e-03 60 1.938888889e-03 60 1.944444444e-03 60 1.950000000e-03 60 1.955555556e-03 60 1.961111111e-03 60 1.966666667e-03 60 1.972222222e-03 60 1.977777778e-03 60 1.983333333e-03 60 1.988888889e-03 60 1.994444444e-03 60 2.000000000e-03 60 2.005555556e-03 60 2.011111111e-03 60 2.016666667e-03 60 2.022222222e-03 60 2.027777778e-03 60 2.033333333e-03 60 2.038888889e-03 60 2.044444444e-03 60 2.050000000e-03 60 2.055555556e-03 60 2.061111111e-03 60 2.066666667e-03 60 2.072222222e-03 60 2.077777778e-03 60 2.083333333e-03 60 2.088888889e-03 60 2.094444444e-03 60 2.100000000e-03 60 2.105555556e-03 60 2.111111111e-03 60 2.116666667e-03 60 2.122222222e-03 60 2.127777778e-03 60 2.133333333e-03 60 2.138888889e-03 60 2.144444444e-03 60 2.150000000e-03 60 2.155555556e-03 60 2.161111111e-03 60 2.166666667e-03 60 2.172222222e-03 60 2.177777778e-03 60 2.183333333e-03 60 2.188888889e-03 60 2.194444444e-03 60 2.200000000e-03 60 2.205555556e-03 60 2.211111111e-03 60 2.216666667e-03 60 2.222222222e-03 60 2.227777778e-03 60 2.233333333e-03 60 2.238888889e-03 60 2.244444444e-03 60 2.250000000e-03 60 2.255555556e-03 60 2.261111111e-03 60 2.266666667e-03 60 2.272222222e-03 60 2.277777778e-03 60 2.283333333e-03 60 2.288888889e-03 60 2.294444444e-03 60 2.300000000e-03 60 2.305555556e-03 60 2.311111111e-03 60 2.316666667e-03 60 2.322222222e-03 60 2.327777778e-03 60 2.333333333e-03 60 2.338888889e-03 60 2.344444444e-03 60 2.350000000e-03 60 2.355555556e-03 60 2.361111111e-03 60 2.366666667e-03 60 2.372222222e-03 60 2.377777778e-03 60 2.383333333e-03 60 2.388888889e-03 60 2.394444444e-03 60 2.400000000e-03 60 2.405555556e-03 60 2.411111111e-03 60 2.416666667e-03 60 2.422222222e-03 60 2.427777778e-03 60 2.433333333e-03 60 2.438888889e-03 60 2.444444444e-03 60 2.450000000e-03 60 2.455555556e-03 60 2.461111111e-03 60 2.466666667e-03 60 2.472222222e-03 60 2.477777778e-03 60 2.483333333e-03 60 2.488888889e-03 60 2.494444444e-03 60 2.500000000e-03 60 2.505555556e-03 60 2.511111111e-03 60 2.516666667e-03 60 2.522222222e-03 60 2.527777778e-03 60 2.533333333e-03 471 2.538888889e-03 471 2.544444444e-03 471 2.550000000e-03 471 2.555555556e-03 471 2.561111111e-03 471 2.566666667e-03 471 2.572222222e-03 471 2.577777778e-03 471 2.583333333e-03 471 2.588888889e-03 471 2.594444444e-03 471 2.600000000e-03 471 2.605555556e-03 471 2.611111111e-03 471 2.616666667e-03 471 2.622222222e-03 471 2.627777778e-03 471 2.633333333e-03 471 2.638888889e-03 471 2.644444444e-03 471 2.650000000e-03 471 2.655555556e-03 471 2.661111111e-03 471 2.666666667e-03 471 2.672222222e-03 471 2.677777778e-03 471 2.683333333e-03 471 2.688888889e-03 471 2.694444444e-03 471 2.700000000e-03 471 2.705555556e-03 471 2.711111111e-03 471 2.716666667e-03 471 2.722222222e-03 471 2.727777778e-03 471 2.733333333e-03 471 2.738888889e-03 471 2.744444444e-03 471 2.750000000e-03 471 2.755555556e-03 471 2.761111111e-03 471 2.766666667e-03 471 2.772222222e-03 471 2.777777778e-03 471 2.783333333e-03 471 2.788888889e-03 471 2.794444444e-03 471 2.800000000e-03 471 2.805555556e-03 471 2.811111111e-03 471 2.816666667e-03 471 2.822222222e-03 471 2.827777778e-03 471 2.833333333e-03 471 2.838888889e-03 471 2.844444444e-03 471 2.850000000e-03 471 2.855555556e-03 471 2.861111111e-03 471 2.866666667e-03 471 2.872222222e-03 471 2.877777778e-03 471 2.883333333e-03 471 2.888888889e-03 471 2.894444444e-03 471 2.900000000e-03 471 2.905555556e-03 471 2.911111111e-03 471 2.916666667e-03 471 2.922222222e-03 471 2.927777778e-03 471 2.933333333e-03 471 2.938888889e-03 471 2.944444444e-03 471 2.950000000e-03 471 2.955555556e-03 471 2.961111111e-03 471 2.966666667e-03 471 2.972222222e-03 471 2.977777778e-03 471 2.983333333e-03 471 2.988888889e-03 471 2.994444444e-03 471 3.000000000e-03 471 3.005555556e-03 471 3.011111111e-03 471 3.016666667e-03 471 3.022222222e-03 471 3.027777778e-03 471 3.033333333e-03 471 3.038888889e-03 471 3.044444444e-03 471 3.050000000e-03 471 3.055555556e-03 471 3.061111111e-03 471 3.066666667e-03 471 3.072222222e-03 471 3.077777778e-03 471 3.083333333e-03 471 3.088888889e-03 471 3.094444444e-03 471 3.100000000e-03 471 3.105555556e-03 471 3.111111111e-03 471 3.116666667e-03 471 3.122222222e-03 471 3.127777778e-03 471 3.133333333e-03 471 3.138888889e-03 471 3.144444444e-03 471 3.150000000e-03 471 3.155555556e-03 471 3.161111111e-03 471 3.166666667e-03 471 3.172222222e-03 471 3.177777778e-03 471 3.183333333e-03 471 3.188888889e-03 471 3.194444444e-03 471 3.200000000e-03 471 3.205555556e-03 471 3.211111111e-03 471 3.216666667e-03 471 3.222222222e-03 471 3.227777778e-03 471 3.233333333e-03 471 3.238888889e-03 471 3.244444444e-03 471 3.250000000e-03 471 3.255555556e-03 471 3.261111111e-03 471 3.266666667e-03 471 3.272222222e-03 471 3.277777778e-03 471 3.283333333e-03 471 3.288888889e-03 471 3.294444444e-03 471 3.300000000e-03 471 3.305555556e-03 471 3.311111111e-03 471 3.316666667e-03 471 3.322222222e-03 471 3.327777778e-03 471 3.333333333e-03 471) r=0
V_Cx3i 7 x_cx3 0
F_Cx3q 0 q_cx3 V_Cx3i 1
C_Cx3q q_cx3 0 1.0e-09
B_Cx3v x_cx3 n17 V='V(q_cx3)*1.0e-09/(1e-12*V(cx3c))'
V_Cx4c cx4c 0 PWL(0.000000000e+00 60 5.555555556e-06 60 1.111111111e-05 60 1.666666667e-05 60 2.222222222e-05 60 2.777777778e-05 60 3.333333333e-05 60 3.888888889e-05 60 4.444444444e-05 60 5.000000000e-05 60 5.555555556e-05 60 6.111111111e-05 60 6.666666667e-05 60 7.222222222e-05 60 7.777777778e-05 60 8.333333333e-05 60 8.888888889e-05 60 9.444444444e-05 60 1.000000000e-04 60 1.055555556e-04 60 1.111111111e-04 60 1.166666667e-04 60 1.222222222e-04 60 1.277777778e-04 60 1.333333333e-04 60 1.388888889e-04 60 1.444444444e-04 60 1.500000000e-04 60 1.555555556e-04 60 1.611111111e-04 60 1.666666667e-04 60 1.722222222e-04 60 1.777777778e-04 60 1.833333333e-04 60 1.888888889e-04 60 1.944444444e-04 60 2.000000000e-04 60 2.055555556e-04 60 2.111111111e-04 60 2.166666667e-04 60 2.222222222e-04 60 2.277777778e-04 60 2.333333333e-04 60 2.388888889e-04 60 2.444444444e-04 60 2.500000000e-04 60 2.555555556e-04 60 2.611111111e-04 60 2.666666667e-04 60 2.722222222e-04 60 2.777777778e-04 60 2.833333333e-04 60 2.888888889e-04 60 2.944444444e-04 60 3.000000000e-04 60 3.055555556e-04 60 3.111111111e-04 60 3.166666667e-04 60 3.222222222e-04 60 3.277777778e-04 60 3.333333333e-04 60 3.388888889e-04 60 3.444444444e-04 60 3.500000000e-04 60 3.555555556e-04 60 3.611111111e-04 60 3.666666667e-04 60 3.722222222e-04 60 3.777777778e-04 60 3.833333333e-04 60 3.888888889e-04 60 3.944444444e-04 60 4.000000000e-04 60 4.055555556e-04 60 4.111111111e-04 60 4.166666667e-04 60 4.222222222e-04 60 4.277777778e-04 60 4.333333333e-04 60 4.388888889e-04 60 4.444444444e-04 60 4.500000000e-04 60 4.555555556e-04 60 4.611111111e-04 60 4.666666667e-04 60 4.722222222e-04 60 4.777777778e-04 60 4.833333333e-04 60 4.888888889e-04 60 4.944444444e-04 60 5.000000000e-04 60 5.055555556e-04 60 5.111111111e-04 60 5.166666667e-04 60 5.222222222e-04 60 5.277777778e-04 60 5.333333333e-04 60 5.388888889e-04 60 5.444444444e-04 60 5.500000000e-04 60 5.555555556e-04 60 5.611111111e-04 60 5.666666667e-04 60 5.722222222e-04 60 5.777777778e-04 60 5.833333333e-04 60 5.888888889e-04 60 5.944444444e-04 60 6.000000000e-04 60 6.055555556e-04 60 6.111111111e-04 60 6.166666667e-04 60 6.222222222e-04 60 6.277777778e-04 60 6.333333333e-04 60 6.388888889e-04 60 6.444444444e-04 60 6.500000000e-04 60 6.555555556e-04 60 6.611111111e-04 60 6.666666667e-04 60 6.722222222e-04 60 6.777777778e-04 60 6.833333333e-04 60 6.888888889e-04 60 6.944444444e-04 60 7.000000000e-04 60 7.055555556e-04 60 7.111111111e-04 60 7.166666667e-04 60 7.222222222e-04 60 7.277777778e-04 60 7.333333333e-04 60 7.388888889e-04 60 7.444444444e-04 60 7.500000000e-04 60 7.555555556e-04 60 7.611111111e-04 60 7.666666667e-04 60 7.722222222e-04 60 7.777777778e-04 60 7.833333333e-04 60 7.888888889e-04 60 7.944444444e-04 60 8.000000000e-04 60 8.055555556e-04 60 8.111111111e-04 60 8.166666667e-04 60 8.222222222e-04 60 8.277777778e-04 60 8.333333333e-04 60 8.388888889e-04 60 8.444444444e-04 60 8.500000000e-04 60 8.555555556e-04 60 8.611111111e-04 60 8.666666667e-04 471 8.722222222e-04 471 8.777777778e-04 471 8.833333333e-04 471 8.888888889e-04 471 8.944444444e-04 471 9.000000000e-04 471 9.055555556e-04 471 9.111111111e-04 471 9.166666667e-04 471 9.222222222e-04 471 9.277777778e-04 471 9.333333333e-04 471 9.388888889e-04 471 9.444444444e-04 471 9.500000000e-04 471 9.555555556e-04 471 9.611111111e-04 471 9.666666667e-04 471 9.722222222e-04 471 9.777777778e-04 471 9.833333333e-04 471 9.888888889e-04 471 9.944444444e-04 471 1.000000000e-03 471 1.005555556e-03 471 1.011111111e-03 471 1.016666667e-03 471 1.022222222e-03 471 1.027777778e-03 471 1.033333333e-03 471 1.038888889e-03 471 1.044444444e-03 471 1.050000000e-03 471 1.055555556e-03 471 1.061111111e-03 471 1.066666667e-03 471 1.072222222e-03 471 1.077777778e-03 471 1.083333333e-03 471 1.088888889e-03 471 1.094444444e-03 471 1.100000000e-03 471 1.105555556e-03 471 1.111111111e-03 471 1.116666667e-03 471 1.122222222e-03 471 1.127777778e-03 471 1.133333333e-03 471 1.138888889e-03 471 1.144444444e-03 471 1.150000000e-03 471 1.155555556e-03 471 1.161111111e-03 471 1.166666667e-03 471 1.172222222e-03 471 1.177777778e-03 471 1.183333333e-03 471 1.188888889e-03 471 1.194444444e-03 471 1.200000000e-03 471 1.205555556e-03 471 1.211111111e-03 471 1.216666667e-03 471 1.222222222e-03 471 1.227777778e-03 471 1.233333333e-03 471 1.238888889e-03 471 1.244444444e-03 471 1.250000000e-03 471 1.255555556e-03 471 1.261111111e-03 471 1.266666667e-03 471 1.272222222e-03 471 1.277777778e-03 471 1.283333333e-03 471 1.288888889e-03 471 1.294444444e-03 471 1.300000000e-03 471 1.305555556e-03 471 1.311111111e-03 471 1.316666667e-03 471 1.322222222e-03 471 1.327777778e-03 471 1.333333333e-03 471 1.338888889e-03 471 1.344444444e-03 471 1.350000000e-03 471 1.355555556e-03 471 1.361111111e-03 471 1.366666667e-03 471 1.372222222e-03 471 1.377777778e-03 471 1.383333333e-03 471 1.388888889e-03 471 1.394444444e-03 471 1.400000000e-03 471 1.405555556e-03 471 1.411111111e-03 471 1.416666667e-03 471 1.422222222e-03 471 1.427777778e-03 471 1.433333333e-03 471 1.438888889e-03 471 1.444444444e-03 471 1.450000000e-03 471 1.455555556e-03 471 1.461111111e-03 471 1.466666667e-03 471 1.472222222e-03 471 1.477777778e-03 471 1.483333333e-03 471 1.488888889e-03 471 1.494444444e-03 471 1.500000000e-03 471 1.505555556e-03 471 1.511111111e-03 471 1.516666667e-03 471 1.522222222e-03 471 1.527777778e-03 471 1.533333333e-03 471 1.538888889e-03 471 1.544444444e-03 471 1.550000000e-03 471 1.555555556e-03 471 1.561111111e-03 471 1.566666667e-03 471 1.572222222e-03 471 1.577777778e-03 471 1.583333333e-03 471 1.588888889e-03 471 1.594444444e-03 471 1.600000000e-03 471 1.605555556e-03 471 1.611111111e-03 471 1.616666667e-03 471 1.622222222e-03 471 1.627777778e-03 471 1.633333333e-03 471 1.638888889e-03 471 1.644444444e-03 471 1.650000000e-03 471 1.655555556e-03 471 1.661111111e-03 471 1.666666667e-03 471 1.672222222e-03 471 1.677777778e-03 471 1.683333333e-03 471 1.688888889e-03 471 1.694444444e-03 471 1.700000000e-03 471 1.705555556e-03 471 1.711111111e-03 471 1.716666667e-03 471 1.722222222e-03 471 1.727777778e-03 471 1.733333333e-03 471 1.738888889e-03 471 1.744444444e-03 471 1.750000000e-03 471 1.755555556e-03 471 1.761111111e-03 471 1.766666667e-03 471 1.772222222e-03 471 1.777777778e-03 471 1.783333333e-03 471 1.788888889e-03 471 1.794444444e-03 471 1.800000000e-03 471 1.805555556e-03 471 1.811111111e-03 471 1.816666667e-03 471 1.822222222e-03 471 1.827777778e-03 471 1.833333333e-03 471 1.838888889e-03 471 1.844444444e-03 471 1.850000000e-03 471 1.855555556e-03 471 1.861111111e-03 471 1.866666667e-03 471 1.872222222e-03 471 1.877777778e-03 471 1.883333333e-03 471 1.888888889e-03 471 1.894444444e-03 471 1.900000000e-03 471 1.905555556e-03 471 1.911111111e-03 471 1.916666667e-03 471 1.922222222e-03 471 1.927777778e-03 471 1.933333333e-03 471 1.938888889e-03 471 1.944444444e-03 471 1.950000000e-03 471 1.955555556e-03 471 1.961111111e-03 471 1.966666667e-03 471 1.972222222e-03 471 1.977777778e-03 471 1.983333333e-03 471 1.988888889e-03 471 1.994444444e-03 471 2.000000000e-03 471 2.005555556e-03 471 2.011111111e-03 471 2.016666667e-03 471 2.022222222e-03 471 2.027777778e-03 471 2.033333333e-03 471 2.038888889e-03 471 2.044444444e-03 471 2.050000000e-03 471 2.055555556e-03 471 2.061111111e-03 471 2.066666667e-03 471 2.072222222e-03 471 2.077777778e-03 471 2.083333333e-03 471 2.088888889e-03 471 2.094444444e-03 471 2.100000000e-03 471 2.105555556e-03 471 2.111111111e-03 471 2.116666667e-03 471 2.122222222e-03 471 2.127777778e-03 471 2.133333333e-03 471 2.138888889e-03 471 2.144444444e-03 471 2.150000000e-03 471 2.155555556e-03 471 2.161111111e-03 471 2.166666667e-03 471 2.172222222e-03 471 2.177777778e-03 471 2.183333333e-03 471 2.188888889e-03 471 2.194444444e-03 471 2.200000000e-03 471 2.205555556e-03 471 2.211111111e-03 471 2.216666667e-03 471 2.222222222e-03 471 2.227777778e-03 471 2.233333333e-03 471 2.238888889e-03 471 2.244444444e-03 471 2.250000000e-03 471 2.255555556e-03 471 2.261111111e-03 471 2.266666667e-03 471 2.272222222e-03 471 2.277777778e-03 471 2.283333333e-03 471 2.288888889e-03 471 2.294444444e-03 471 2.300000000e-03 471 2.305555556e-03 471 2.311111111e-03 471 2.316666667e-03 471 2.322222222e-03 471 2.327777778e-03 471 2.333333333e-03 471 2.338888889e-03 471 2.344444444e-03 471 2.350000000e-03 471 2.355555556e-03 471 2.361111111e-03 471 2.366666667e-03 471 2.372222222e-03 471 2.377777778e-03 471 2.383333333e-03 471 2.388888889e-03 471 2.394444444e-03 471 2.400000000e-03 471 2.405555556e-03 471 2.411111111e-03 471 2.416666667e-03 471 2.422222222e-03 471 2.427777778e-03 471 2.433333333e-03 471 2.438888889e-03 471 2.444444444e-03 471 2.450000000e-03 471 2.455555556e-03 471 2.461111111e-03 471 2.466666667e-03 471 2.472222222e-03 471 2.477777778e-03 471 2.483333333e-03 471 2.488888889e-03 471 2.494444444e-03 471 2.500000000e-03 471 2.505555556e-03 471 2.511111111e-03 471 2.516666667e-03 471 2.522222222e-03 471 2.527777778e-03 471 2.533333333e-03 471 2.538888889e-03 470.913 2.544444444e-03 470.652 2.550000000e-03 470.218 2.555555556e-03 469.61 2.561111111e-03 468.83 2.566666667e-03 467.878 2.572222222e-03 466.754 2.577777778e-03 465.461 2.583333333e-03 463.998 2.588888889e-03 462.367 2.594444444e-03 460.569 2.600000000e-03 458.607 2.605555556e-03 456.481 2.611111111e-03 454.193 2.616666667e-03 451.746 2.622222222e-03 449.142 2.627777778e-03 446.381 2.633333333e-03 443.468 2.638888889e-03 440.404 2.644444444e-03 437.193 2.650000000e-03 433.836 2.655555556e-03 430.336 2.661111111e-03 426.697 2.666666667e-03 422.922 2.672222222e-03 419.014 2.677777778e-03 414.975 2.683333333e-03 410.81 2.688888889e-03 406.523 2.694444444e-03 402.116 2.700000000e-03 397.593 2.705555556e-03 392.958 2.711111111e-03 388.216 2.716666667e-03 383.37 2.722222222e-03 378.424 2.727777778e-03 373.383 2.733333333e-03 368.25 2.738888889e-03 363.03 2.744444444e-03 357.728 2.750000000e-03 352.348 2.755555556e-03 346.894 2.761111111e-03 341.372 2.766666667e-03 335.785 2.772222222e-03 330.139 2.777777778e-03 324.438 2.783333333e-03 318.687 2.788888889e-03 312.892 2.794444444e-03 307.056 2.800000000e-03 301.185 2.805555556e-03 295.283 2.811111111e-03 289.357 2.816666667e-03 283.411 2.822222222e-03 277.449 2.827777778e-03 271.477 2.833333333e-03 265.5 2.838888889e-03 259.523 2.844444444e-03 253.551 2.850000000e-03 247.589 2.855555556e-03 241.643 2.861111111e-03 235.717 2.866666667e-03 229.815 2.872222222e-03 223.944 2.877777778e-03 218.108 2.883333333e-03 212.313 2.888888889e-03 206.562 2.894444444e-03 200.861 2.900000000e-03 195.215 2.905555556e-03 189.628 2.911111111e-03 184.106 2.916666667e-03 178.652 2.922222222e-03 173.272 2.927777778e-03 167.97 2.933333333e-03 162.75 2.938888889e-03 157.617 2.944444444e-03 152.576 2.950000000e-03 147.63 2.955555556e-03 142.784 2.961111111e-03 138.042 2.966666667e-03 133.407 2.972222222e-03 128.884 2.977777778e-03 124.477 2.983333333e-03 120.19 2.988888889e-03 116.025 2.994444444e-03 111.986 3.000000000e-03 108.078 3.005555556e-03 104.303 3.011111111e-03 100.664 3.016666667e-03 97.1643 3.022222222e-03 93.8073 3.027777778e-03 90.5955 3.033333333e-03 87.5318 3.038888889e-03 84.6186 3.044444444e-03 81.8585 3.050000000e-03 79.2537 3.055555556e-03 76.8066 3.061111111e-03 74.5191 3.066666667e-03 72.3932 3.072222222e-03 70.4306 3.077777778e-03 68.6332 3.083333333e-03 67.0022 3.088888889e-03 65.5393 3.094444444e-03 64.2455 3.100000000e-03 63.122 3.105555556e-03 62.1697 3.111111111e-03 61.3895 3.116666667e-03 60.782 3.122222222e-03 60.3477 3.127777778e-03 60.0869 3.133333333e-03 60 3.138888889e-03 60 3.144444444e-03 60 3.150000000e-03 60 3.155555556e-03 60 3.161111111e-03 60 3.166666667e-03 60 3.172222222e-03 60 3.177777778e-03 60 3.183333333e-03 60 3.188888889e-03 60 3.194444444e-03 60 3.200000000e-03 60 3.205555556e-03 60 3.211111111e-03 60 3.216666667e-03 60 3.222222222e-03 60 3.227777778e-03 60 3.233333333e-03 60 3.238888889e-03 60 3.244444444e-03 60 3.250000000e-03 60 3.255555556e-03 60 3.261111111e-03 60 3.266666667e-03 60 3.272222222e-03 60 3.277777778e-03 60 3.283333333e-03 60 3.288888889e-03 60 3.294444444e-03 60 3.300000000e-03 60 3.305555556e-03 60 3.311111111e-03 60 3.316666667e-03 60 3.322222222e-03 60 3.327777778e-03 60 3.333333333e-03 60) r=0
V_Cx4i n23 x_cx4 0
F_Cx4q 0 q_cx4 V_Cx4i 1
C_Cx4q q_cx4 0 1.0e-09
B_Cx4v x_cx4 8 V='V(q_cx4)*1.0e-09/(1e-12*V(cx4c))'
L_Lx3 n17 r_lx3 1.000000e-03
R_Lx3esr r_lx3 3 20
L_Lx4 2 r_lx4 1.000000e-03
R_Lx4esr r_lx4 n23 20
V_sBS3 7 s_bs3 0
XBS3 s_bs3 3 mbi_bs3 mf_bs3 mr_bs3 ia2_gap
V_mbi_bs3 mbi_bs3 0 PWL(0.000000000e+00 0 1.055557556e-03 0 1.056057556e-03 1 1.500002000e-03 1 1.500502000e-03 0 4.388890889e-03 0 4.389390889e-03 1 4.833335333e-03 1
+ 4.833835333e-03 0 7.722224222e-03 0 7.722724222e-03 1 8.166668667e-03 1 8.167168667e-03 0 1.105555756e-02 0 1.105605756e-02 1 1.150000200e-02 1
+ 1.150050200e-02 0 1.438889089e-02 0 1.438939089e-02 1 1.483333533e-02 1 1.483383533e-02 0 1.772222422e-02 0 1.772272422e-02 1 1.816666867e-02 1
+ 1.816716867e-02 0 2.105555756e-02 0 2.105605756e-02 1 2.150000200e-02 1 2.150050200e-02 0 2.438889089e-02 0 2.438939089e-02 1 2.483333533e-02 1
+ 2.483383533e-02 0 2.772222422e-02 0 2.772272422e-02 1 2.816666867e-02 1 2.816716867e-02 0 3.105555756e-02 0 3.105605756e-02 1 3.150000200e-02 1
+ 3.150050200e-02 0 3.438889089e-02 0 3.438939089e-02 1 3.483333533e-02 1 3.483383533e-02 0 3.772222422e-02 0 3.772272422e-02 1 3.816666867e-02 1
+ 3.816716867e-02 0 4.105555756e-02 0 4.105605756e-02 1 4.150000200e-02 1 4.150050200e-02 0 4.433333333e-02 0)
V_mf_bs3 mf_bs3 0 PWL(0.000000000e+00 0 4.433333333e-02 0)
V_mr_bs3 mr_bs3 0 PWL(0.000000000e+00 0 4.433333333e-02 0)
V_sBS4 8 s_bs4 0
XBS4 s_bs4 2 mbi_bs4 mf_bs4 mr_bs4 ia2_gap
V_mbi_bs4 mbi_bs4 0 PWL(0.000000000e+00 0 2.722224222e-03 0 2.722724222e-03 1 3.166668667e-03 1 3.167168667e-03 0 6.055557556e-03 0 6.056057556e-03 1 6.500002000e-03 1
+ 6.500502000e-03 0 9.388890889e-03 0 9.389390889e-03 1 9.833335333e-03 1 9.833835333e-03 0 1.272222422e-02 0 1.272272422e-02 1 1.316666867e-02 1
+ 1.316716867e-02 0 1.605555756e-02 0 1.605605756e-02 1 1.650000200e-02 1 1.650050200e-02 0 1.938889089e-02 0 1.938939089e-02 1 1.983333533e-02 1
+ 1.983383533e-02 0 2.272222422e-02 0 2.272272422e-02 1 2.316666867e-02 1 2.316716867e-02 0 2.605555756e-02 0 2.605605756e-02 1 2.650000200e-02 1
+ 2.650050200e-02 0 2.938889089e-02 0 2.938939089e-02 1 2.983333533e-02 1 2.983383533e-02 0 3.272222422e-02 0 3.272272422e-02 1 3.316666867e-02 1
+ 3.316716867e-02 0 3.605555756e-02 0 3.605605756e-02 1 3.650000200e-02 1 3.650050200e-02 0 3.938889089e-02 0 3.938939089e-02 1 3.983333533e-02 1
+ 3.983383533e-02 0 4.272222422e-02 0 4.272272422e-02 1 4.316666867e-02 1 4.316716867e-02 0 4.433333333e-02 0)
V_mf_bs4 mf_bs4 0 PWL(0.000000000e+00 0 4.433333333e-02 0)
V_mr_bs4 mr_bs4 0 PWL(0.000000000e+00 0 4.433333333e-02 0)
V_sSG1 2 s_sg1 0
XSG1 s_sg1 0 mbi_sg1 mf_sg1 mr_sg1 ia2_gap
V_mbi_sg1 mbi_sg1 0 PWL(0.000000000e+00 0 4.433333333e-02 0)
V_mf_sg1 mf_sg1 0 PWL(0.000000000e+00 0 1.666686667e-04 0 1.671686667e-04 1 1.500002000e-03 1 1.500502000e-03 0 3.500002000e-03 0 3.500502000e-03 1 4.833335333e-03 1
+ 4.833835333e-03 0 6.833335333e-03 0 6.833835333e-03 1 8.166668667e-03 1 8.167168667e-03 0 1.016666867e-02 0 1.016716867e-02 1 1.150000200e-02 1
+ 1.150050200e-02 0 1.350000200e-02 0 1.350050200e-02 1 1.483333533e-02 1 1.483383533e-02 0 1.683333533e-02 0 1.683383533e-02 1 1.816666867e-02 1
+ 1.816716867e-02 0 2.016666867e-02 0 2.016716867e-02 1 2.150000200e-02 1 2.150050200e-02 0 2.350000200e-02 0 2.350050200e-02 1 2.483333533e-02 1
+ 2.483383533e-02 0 2.683333533e-02 0 2.683383533e-02 1 2.816666867e-02 1 2.816716867e-02 0 3.016666867e-02 0 3.016716867e-02 1 3.150000200e-02 1
+ 3.150050200e-02 0 3.350000200e-02 0 3.350050200e-02 1 3.483333533e-02 1 3.483383533e-02 0 3.683333533e-02 0 3.683383533e-02 1 3.816666867e-02 1
+ 3.816716867e-02 0 4.016666867e-02 0 4.016716867e-02 1 4.150000200e-02 1 4.150050200e-02 0 4.433333333e-02 0)
V_mr_sg1 mr_sg1 0 PWL(0.000000000e+00 0 4.433333333e-02 0)
V_sSG2 3 s_sg2 0
XSG2 s_sg2 0 mbi_sg2 mf_sg2 mr_sg2 ia2_gap
V_mbi_sg2 mbi_sg2 0 PWL(0.000000000e+00 0 4.433333333e-02 0)
V_mf_sg2 mf_sg2 0 PWL(0.000000000e+00 0 1.833335333e-03 0 1.833835333e-03 1 3.166668667e-03 1 3.167168667e-03 0 5.166668667e-03 0 5.167168667e-03 1 6.500002000e-03 1
+ 6.500502000e-03 0 8.500002000e-03 0 8.500502000e-03 1 9.833335333e-03 1 9.833835333e-03 0 1.183333533e-02 0 1.183383533e-02 1 1.316666867e-02 1
+ 1.316716867e-02 0 1.516666867e-02 0 1.516716867e-02 1 1.650000200e-02 1 1.650050200e-02 0 1.850000200e-02 0 1.850050200e-02 1 1.983333533e-02 1
+ 1.983383533e-02 0 2.183333533e-02 0 2.183383533e-02 1 2.316666867e-02 1 2.316716867e-02 0 2.516666867e-02 0 2.516716867e-02 1 2.650000200e-02 1
+ 2.650050200e-02 0 2.850000200e-02 0 2.850050200e-02 1 2.983333533e-02 1 2.983383533e-02 0 3.183333533e-02 0 3.183383533e-02 1 3.316666867e-02 1
+ 3.316716867e-02 0 3.516666867e-02 0 3.516716867e-02 1 3.650000200e-02 1 3.650050200e-02 0 3.850000200e-02 0 3.850050200e-02 1 3.983333533e-02 1
+ 3.983383533e-02 0 4.183333533e-02 0 4.183383533e-02 1 4.316666867e-02 1 4.316716867e-02 0 4.433333333e-02 0)
V_mr_sg2 mr_sg2 0 PWL(0.000000000e+00 0 4.433333333e-02 0)
V_sSG3a1 1 s_sg3a1 0
XSG3a1 s_sg3a1 7 mbi_sg3a1 mf_sg3a1 mr_sg3a1 ia2_gap
V_mbi_sg3a1 mbi_sg3a1 0 PWL(0.000000000e+00 0 4.000020000e-04 0 4.005020000e-04 1 4.249969231e-04 1 4.250069231e-04 0 4.253918478e-04 0 4.254018478e-04 1 4.503360784e-04 1
+ 4.503460784e-04 0 4.507009642e-04 0 4.507109642e-04 1 4.756743563e-04 1 4.756843563e-04 0 4.760389275e-04 0 4.760489275e-04 1 5.010125012e-04 1
+ 5.010225012e-04 0 5.013770732e-04 0 5.013870732e-04 1 5.263505210e-04 1 5.263605210e-04 0 5.267153113e-04 0 5.267253113e-04 1 5.516884442e-04 1
+ 5.516984442e-04 0 5.520535678e-04 0 5.520635678e-04 1 5.770265785e-04 1 5.770365785e-04 0 5.773915778e-04 0 5.774015778e-04 1 6.023647796e-04 1
+ 6.023747796e-04 0 6.027295720e-04 0 6.027395720e-04 1 6.277031057e-04 1 6.277131057e-04 0 6.280675213e-04 0 6.280775213e-04 1 6.530410964e-04 1
+ 6.530510964e-04 0 6.534058255e-04 0 6.534158255e-04 1 6.783791576e-04 1 6.783891576e-04 0 6.787439889e-04 0 6.787539889e-04 1 7.037169799e-04 1
+ 7.037269799e-04 0 7.040823152e-04 0 7.040923152e-04 1 7.290553738e-04 1 7.290653738e-04 0 7.294200694e-04 0 7.294300694e-04 1 7.543933927e-04 1
+ 7.544033927e-04 0 7.547582864e-04 0 7.547682864e-04 1 7.797319657e-04 1 7.797419657e-04 0 7.800960146e-04 0 7.801060146e-04 1 8.050694723e-04 1
+ 8.050794723e-04 0 8.054347887e-04 0 8.054447887e-04 1 8.304080237e-04 1 8.304180237e-04 0 8.307724168e-04 0 8.307824168e-04 1 8.550617561e-04 1
+ 8.550717561e-04 0 8.554252399e-04 0 8.554352399e-04 1 8.797148363e-04 1 8.797248363e-04 0 8.800786831e-04 0 8.800886831e-04 1 8.916686667e-04 1
+ 8.916786667e-04 0 3.733335333e-03 0 3.733835333e-03 1 3.758330069e-03 1 3.758340069e-03 0 3.758725110e-03 0 3.758735110e-03 1 3.783669185e-03 1
+ 3.783679185e-03 0 3.784034154e-03 0 3.784044154e-03 1 3.809007442e-03 1 3.809017442e-03 0 3.809372112e-03 0 3.809382112e-03 1 3.834345647e-03 1
+ 3.834355647e-03 0 3.834710187e-03 0 3.834720187e-03 1 3.859683703e-03 1 3.859693703e-03 0 3.860048406e-03 0 3.860058406e-03 1 3.885021645e-03 1
+ 3.885031645e-03 0 3.885386670e-03 0 3.885396670e-03 1 3.910359693e-03 1 3.910369693e-03 0 3.910724771e-03 0 3.910734771e-03 1 3.935697885e-03 1
+ 3.935707885e-03 0 3.936062751e-03 0 3.936072751e-03 1 3.961036180e-03 1 3.961046180e-03 0 3.961400707e-03 0 3.961410707e-03 1 3.986374301e-03 1
+ 3.986384301e-03 0 3.986738882e-03 0 3.986748882e-03 1 4.011712314e-03 1 4.011722314e-03 0 4.012077123e-03 0 4.012087123e-03 1 4.037050215e-03 1
+ 4.037060215e-03 0 4.037415392e-03 0 4.037425392e-03 1 4.062388391e-03 1 4.062398391e-03 0 4.062753356e-03 0 4.062763356e-03 1 4.087726580e-03 1
+ 4.087736580e-03 0 4.088091369e-03 0 4.088101369e-03 1 4.113064947e-03 1 4.113074947e-03 0 4.113429287e-03 0 4.113439287e-03 1 4.138402861e-03 1
+ 4.138412861e-03 0 4.138767670e-03 0 4.138777670e-03 1 4.163740977e-03 1 4.163750977e-03 0 4.164105770e-03 0 4.164115770e-03 1 4.189078711e-03 1
+ 4.189088711e-03 0 4.189444176e-03 0 4.189454176e-03 1 4.214417255e-03 1 4.214427255e-03 0 4.214781780e-03 0 4.214791780e-03 1 4.225002000e-03 1
+ 4.225012000e-03 0 7.066668667e-03 0 7.067168667e-03 1 7.091663426e-03 1 7.091673426e-03 0 7.092058472e-03 0 7.092068472e-03 1 7.117002540e-03 1
+ 7.117012540e-03 0 7.117367507e-03 0 7.117377507e-03 1 7.142340792e-03 1 7.142350792e-03 0 7.142705469e-03 0 7.142715469e-03 1 7.167678997e-03 1
+ 7.167688997e-03 0 7.168043543e-03 0 7.168053543e-03 1 7.193017056e-03 1 7.193027056e-03 0 7.193381758e-03 0 7.193391758e-03 1 7.218355003e-03 1
+ 7.218365003e-03 0 7.218720019e-03 0 7.218730019e-03 1 7.243693050e-03 1 7.243703050e-03 0 7.244058123e-03 0 7.244068123e-03 1 7.269031239e-03 1
+ 7.269041239e-03 0 7.269396107e-03 0 7.269406107e-03 1 7.294369528e-03 1 7.294379528e-03 0 7.294734066e-03 0 7.294744066e-03 1 7.319707653e-03 1
+ 7.319717653e-03 0 7.320072235e-03 0 7.320082235e-03 1 7.345045668e-03 1 7.345055668e-03 0 7.345410474e-03 0 7.345420474e-03 1 7.370383576e-03 1
+ 7.370393576e-03 0 7.370748739e-03 0 7.370758739e-03 1 7.395721743e-03 1 7.395731743e-03 0 7.396086713e-03 0 7.396096713e-03 1 7.421059935e-03 1
+ 7.421069935e-03 0 7.421424723e-03 0 7.421434723e-03 1 7.446398290e-03 1 7.446408290e-03 0 7.446762651e-03 0 7.446772651e-03 1 7.471736221e-03 1
+ 7.471746221e-03 0 7.472101015e-03 0 7.472111015e-03 1 7.497074325e-03 1 7.497084325e-03 0 7.497439128e-03 0 7.497449128e-03 1 7.522412083e-03 1
+ 7.522422083e-03 0 7.522777512e-03 0 7.522787512e-03 1 7.547750590e-03 1 7.547760590e-03 0 7.548115153e-03 0 7.548125153e-03 1 7.558335333e-03 1
+ 7.558345333e-03 0 1.040000200e-02 0 1.040050200e-02 1 1.042499675e-02 1 1.042500675e-02 0 1.042539180e-02 0 1.042540180e-02 1 1.045033587e-02 1
+ 1.045034587e-02 0 1.045070083e-02 0 1.045071083e-02 1 1.047567412e-02 1 1.047568412e-02 0 1.047603880e-02 0 1.047604880e-02 1 1.050101232e-02 1
+ 1.050102232e-02 0 1.050137687e-02 0 1.050138687e-02 1 1.052635038e-02 1 1.052636038e-02 0 1.052671508e-02 0 1.052672508e-02 1 1.055168833e-02 1
+ 1.055169833e-02 0 1.055205335e-02 0 1.055206335e-02 1 1.057702638e-02 1 1.057703638e-02 0 1.057739145e-02 0 1.057740145e-02 1 1.060236456e-02 1
+ 1.060237456e-02 0 1.060272943e-02 0 1.060273943e-02 1 1.062770285e-02 1 1.062771285e-02 0 1.062806739e-02 0 1.062807739e-02 1 1.065304098e-02 1
+ 1.065305098e-02 0 1.065340556e-02 0 1.065341556e-02 1 1.067837899e-02 1 1.067838899e-02 0 1.067874380e-02 0 1.067875380e-02 1 1.070371690e-02 1
+ 1.070372690e-02 0 1.070408207e-02 0 1.070409207e-02 1 1.072905507e-02 1 1.072906507e-02 0 1.072942004e-02 0 1.072943004e-02 1 1.075439326e-02 1
+ 1.075440326e-02 0 1.075475805e-02 0 1.075476805e-02 1 1.077973162e-02 1 1.077974162e-02 0 1.078009598e-02 0 1.078010598e-02 1 1.080506955e-02 1
+ 1.080507955e-02 0 1.080543434e-02 0 1.080544434e-02 1 1.083040765e-02 1 1.083041765e-02 0 1.083077246e-02 0 1.083078246e-02 1 1.085574541e-02 1
+ 1.085575541e-02 0 1.085611084e-02 0 1.085612084e-02 1 1.088108391e-02 1 1.088109391e-02 0 1.088144848e-02 0 1.088145848e-02 1 1.089166867e-02 1
+ 1.089167867e-02 0 1.373333533e-02 0 1.373383533e-02 1 1.375833008e-02 1 1.375834008e-02 0 1.375872513e-02 0 1.375873513e-02 1 1.378366920e-02 1
+ 1.378367920e-02 0 1.378403417e-02 0 1.378404417e-02 1 1.380900745e-02 1 1.380901745e-02 0 1.380937213e-02 0 1.380938213e-02 1 1.383434566e-02 1
+ 1.383435566e-02 0 1.383471020e-02 0 1.383472020e-02 1 1.385968371e-02 1 1.385969371e-02 0 1.386004841e-02 0 1.386005841e-02 1 1.388502166e-02 1
+ 1.388503166e-02 0 1.388538668e-02 0 1.388539668e-02 1 1.391035971e-02 1 1.391036971e-02 0 1.391072478e-02 0 1.391073478e-02 1 1.393569790e-02 1
+ 1.393570790e-02 0 1.393606277e-02 0 1.393607277e-02 1 1.396103619e-02 1 1.396104619e-02 0 1.396140072e-02 0 1.396141072e-02 1 1.398637431e-02 1
+ 1.398638431e-02 0 1.398673889e-02 0 1.398674889e-02 1 1.401171233e-02 1 1.401172233e-02 0 1.401207713e-02 0 1.401208713e-02 1 1.403705023e-02 1
+ 1.403706023e-02 0 1.403741540e-02 0 1.403742540e-02 1 1.406238840e-02 1 1.406239840e-02 0 1.406275337e-02 0 1.406276337e-02 1 1.408772659e-02 1
+ 1.408773659e-02 0 1.408809138e-02 0 1.408810138e-02 1 1.411306495e-02 1 1.411307495e-02 0 1.411342931e-02 0 1.411343931e-02 1 1.413840288e-02 1
+ 1.413841288e-02 0 1.413876767e-02 0 1.413877767e-02 1 1.416374098e-02 1 1.416375098e-02 0 1.416410579e-02 0 1.416411579e-02 1 1.418907874e-02 1
+ 1.418908874e-02 0 1.418944417e-02 0 1.418945417e-02 1 1.421441724e-02 1 1.421442724e-02 0 1.421478181e-02 0 1.421479181e-02 1 1.422500200e-02 1
+ 1.422501200e-02 0 1.706666867e-02 0 1.706716867e-02 1 1.709166341e-02 1 1.709167341e-02 0 1.709205846e-02 0 1.709206846e-02 1 1.711700253e-02 1
+ 1.711701253e-02 0 1.711736750e-02 0 1.711737750e-02 1 1.714234078e-02 1 1.714235078e-02 0 1.714270546e-02 0 1.714271546e-02 1 1.716767899e-02 1
+ 1.716768899e-02 0 1.716804353e-02 0 1.716805353e-02 1 1.719301705e-02 1 1.719302705e-02 0 1.719338175e-02 0 1.719339175e-02 1 1.721835499e-02 1
+ 1.721836499e-02 0 1.721872001e-02 0 1.721873001e-02 1 1.724369304e-02 1 1.724370304e-02 0 1.724405811e-02 0 1.724406811e-02 1 1.726903123e-02 1
+ 1.726904123e-02 0 1.726939610e-02 0 1.726940610e-02 1 1.729436952e-02 1 1.729437952e-02 0 1.729473405e-02 0 1.729474405e-02 1 1.731970764e-02 1
+ 1.731971764e-02 0 1.732007222e-02 0 1.732008222e-02 1 1.734504566e-02 1 1.734505566e-02 0 1.734541046e-02 0 1.734542046e-02 1 1.737038356e-02 1
+ 1.737039356e-02 0 1.737074873e-02 0 1.737075873e-02 1 1.739572173e-02 1 1.739573173e-02 0 1.739608670e-02 0 1.739609670e-02 1 1.742105992e-02 1
+ 1.742106992e-02 0 1.742142471e-02 0 1.742143471e-02 1 1.744639828e-02 1 1.744640828e-02 0 1.744676264e-02 0 1.744677264e-02 1 1.747173621e-02 1
+ 1.747174621e-02 0 1.747210100e-02 0 1.747211100e-02 1 1.749707431e-02 1 1.749708431e-02 0 1.749743912e-02 0 1.749744912e-02 1 1.752241207e-02 1
+ 1.752242207e-02 0 1.752277750e-02 0 1.752278750e-02 1 1.754775057e-02 1 1.754776057e-02 0 1.754811515e-02 0 1.754812515e-02 1 1.755833533e-02 1
+ 1.755834533e-02 0 2.040000200e-02 0 2.040050200e-02 1 2.042499674e-02 1 2.042500674e-02 0 2.042539179e-02 0 2.042540179e-02 1 2.045033585e-02 1
+ 2.045034585e-02 0 2.045070083e-02 0 2.045071083e-02 1 2.047567411e-02 1 2.047568411e-02 0 2.047603879e-02 0 2.047604879e-02 1 2.050101232e-02 1
+ 2.050102232e-02 0 2.050137686e-02 0 2.050138686e-02 1 2.052635038e-02 1 2.052636038e-02 0 2.052671507e-02 0 2.052672507e-02 1 2.055168832e-02 1
+ 2.055169832e-02 0 2.055205334e-02 0 2.055206334e-02 1 2.057702636e-02 1 2.057703636e-02 0 2.057739144e-02 0 2.057740144e-02 1 2.060236455e-02 1
+ 2.060237455e-02 0 2.060272942e-02 0 2.060273942e-02 1 2.062770285e-02 1 2.062771285e-02 0 2.062806738e-02 0 2.062807738e-02 1 2.065304097e-02 1
+ 2.065305097e-02 0 2.065340555e-02 0 2.065341555e-02 1 2.067837899e-02 1 2.067838899e-02 0 2.067874379e-02 0 2.067875379e-02 1 2.070371689e-02 1
+ 2.070372689e-02 0 2.070408206e-02 0 2.070409206e-02 1 2.072905506e-02 1 2.072906506e-02 0 2.072942003e-02 0 2.072943003e-02 1 2.075439325e-02 1
+ 2.075440325e-02 0 2.075475804e-02 0 2.075476804e-02 1 2.077973161e-02 1 2.077974161e-02 0 2.078009597e-02 0 2.078010597e-02 1 2.080506954e-02 1
+ 2.080507954e-02 0 2.080543433e-02 0 2.080544433e-02 1 2.083040764e-02 1 2.083041764e-02 0 2.083077245e-02 0 2.083078245e-02 1 2.085574540e-02 1
+ 2.085575540e-02 0 2.085611083e-02 0 2.085612083e-02 1 2.088108390e-02 1 2.088109390e-02 0 2.088144847e-02 0 2.088145847e-02 1 2.089166867e-02 1
+ 2.089167867e-02 0 2.373333533e-02 0 2.373383533e-02 1 2.375833007e-02 1 2.375834007e-02 0 2.375872512e-02 0 2.375873512e-02 1 2.378366919e-02 1
+ 2.378367919e-02 0 2.378403416e-02 0 2.378404416e-02 1 2.380900744e-02 1 2.380901744e-02 0 2.380937212e-02 0 2.380938212e-02 1 2.383434565e-02 1
+ 2.383435565e-02 0 2.383471019e-02 0 2.383472019e-02 1 2.385968371e-02 1 2.385969371e-02 0 2.386004840e-02 0 2.386005840e-02 1 2.388502165e-02 1
+ 2.388503165e-02 0 2.388538667e-02 0 2.388539667e-02 1 2.391035970e-02 1 2.391036970e-02 0 2.391072477e-02 0 2.391073477e-02 1 2.393569788e-02 1
+ 2.393570788e-02 0 2.393606276e-02 0 2.393607276e-02 1 2.396103618e-02 1 2.396104618e-02 0 2.396140071e-02 0 2.396141071e-02 1 2.398637430e-02 1
+ 2.398638430e-02 0 2.398673888e-02 0 2.398674888e-02 1 2.401171232e-02 1 2.401172232e-02 0 2.401207712e-02 0 2.401208712e-02 1 2.403705022e-02 1
+ 2.403706022e-02 0 2.403741539e-02 0 2.403742539e-02 1 2.406238839e-02 1 2.406239839e-02 0 2.406275336e-02 0 2.406276336e-02 1 2.408772658e-02 1
+ 2.408773658e-02 0 2.408809137e-02 0 2.408810137e-02 1 2.411306494e-02 1 2.411307494e-02 0 2.411342930e-02 0 2.411343930e-02 1 2.413840287e-02 1
+ 2.413841287e-02 0 2.413876766e-02 0 2.413877766e-02 1 2.416374097e-02 1 2.416375097e-02 0 2.416410578e-02 0 2.416411578e-02 1 2.418907873e-02 1
+ 2.418908873e-02 0 2.418944416e-02 0 2.418945416e-02 1 2.421441723e-02 1 2.421442723e-02 0 2.421478181e-02 0 2.421479181e-02 1 2.422500200e-02 1
+ 2.422501200e-02 0 2.706666867e-02 0 2.706716867e-02 1 2.709166341e-02 1 2.709167341e-02 0 2.709205846e-02 0 2.709206846e-02 1 2.711700252e-02 1
+ 2.711701252e-02 0 2.711736749e-02 0 2.711737749e-02 1 2.714234078e-02 1 2.714235078e-02 0 2.714270545e-02 0 2.714271545e-02 1 2.716767898e-02 1
+ 2.716768898e-02 0 2.716804353e-02 0 2.716805353e-02 1 2.719301704e-02 1 2.719302704e-02 0 2.719338174e-02 0 2.719339174e-02 1 2.721835499e-02 1
+ 2.721836499e-02 0 2.721872000e-02 0 2.721873000e-02 1 2.724369303e-02 1 2.724370303e-02 0 2.724405811e-02 0 2.724406811e-02 1 2.726903122e-02 1
+ 2.726904122e-02 0 2.726939609e-02 0 2.726940609e-02 1 2.729436951e-02 1 2.729437951e-02 0 2.729473405e-02 0 2.729474405e-02 1 2.731970764e-02 1
+ 2.731971764e-02 0 2.732007222e-02 0 2.732008222e-02 1 2.734504565e-02 1 2.734505565e-02 0 2.734541046e-02 0 2.734542046e-02 1 2.737038356e-02 1
+ 2.737039356e-02 0 2.737074872e-02 0 2.737075872e-02 1 2.739572173e-02 1 2.739573173e-02 0 2.739608670e-02 0 2.739609670e-02 1 2.742105992e-02 1
+ 2.742106992e-02 0 2.742142471e-02 0 2.742143471e-02 1 2.744639827e-02 1 2.744640827e-02 0 2.744676263e-02 0 2.744677263e-02 1 2.747173621e-02 1
+ 2.747174621e-02 0 2.747210100e-02 0 2.747211100e-02 1 2.749707431e-02 1 2.749708431e-02 0 2.749743911e-02 0 2.749744911e-02 1 2.752241207e-02 1
+ 2.752242207e-02 0 2.752277750e-02 0 2.752278750e-02 1 2.754775057e-02 1 2.754776057e-02 0 2.754811514e-02 0 2.754812514e-02 1 2.755833533e-02 1
+ 2.755834533e-02 0 3.040000200e-02 0 3.040050200e-02 1 3.042499675e-02 1 3.042500675e-02 0 3.042539180e-02 0 3.042540180e-02 1 3.045033587e-02 1
+ 3.045034587e-02 0 3.045070083e-02 0 3.045071083e-02 1 3.047567412e-02 1 3.047568412e-02 0 3.047603880e-02 0 3.047604880e-02 1 3.050101232e-02 1
+ 3.050102232e-02 0 3.050137687e-02 0 3.050138687e-02 1 3.052635038e-02 1 3.052636038e-02 0 3.052671508e-02 0 3.052672508e-02 1 3.055168833e-02 1
+ 3.055169833e-02 0 3.055205334e-02 0 3.055206334e-02 1 3.057702638e-02 1 3.057703638e-02 0 3.057739145e-02 0 3.057740145e-02 1 3.060236456e-02 1
+ 3.060237456e-02 0 3.060272943e-02 0 3.060273943e-02 1 3.062770285e-02 1 3.062771285e-02 0 3.062806739e-02 0 3.062807739e-02 1 3.065304098e-02 1
+ 3.065305098e-02 0 3.065340556e-02 0 3.065341556e-02 1 3.067837899e-02 1 3.067838899e-02 0 3.067874380e-02 0 3.067875380e-02 1 3.070371690e-02 1
+ 3.070372690e-02 0 3.070408207e-02 0 3.070409207e-02 1 3.072905507e-02 1 3.072906507e-02 0 3.072942004e-02 0 3.072943004e-02 1 3.075439326e-02 1
+ 3.075440326e-02 0 3.075475805e-02 0 3.075476805e-02 1 3.077973162e-02 1 3.077974162e-02 0 3.078009598e-02 0 3.078010598e-02 1 3.080506955e-02 1
+ 3.080507955e-02 0 3.080543434e-02 0 3.080544434e-02 1 3.083040765e-02 1 3.083041765e-02 0 3.083077246e-02 0 3.083078246e-02 1 3.085574541e-02 1
+ 3.085575541e-02 0 3.085611084e-02 0 3.085612084e-02 1 3.088108391e-02 1 3.088109391e-02 0 3.088144848e-02 0 3.088145848e-02 1 3.089166867e-02 1
+ 3.089167867e-02 0 3.373333533e-02 0 3.373383533e-02 1 3.375833008e-02 1 3.375834008e-02 0 3.375872513e-02 0 3.375873513e-02 1 3.378366919e-02 1
+ 3.378367919e-02 0 3.378403416e-02 0 3.378404416e-02 1 3.380900744e-02 1 3.380901744e-02 0 3.380937212e-02 0 3.380938212e-02 1 3.383434565e-02 1
+ 3.383435565e-02 0 3.383471019e-02 0 3.383472019e-02 1 3.385968371e-02 1 3.385969371e-02 0 3.386004841e-02 0 3.386005841e-02 1 3.388502166e-02 1
+ 3.388503166e-02 0 3.388538667e-02 0 3.388539667e-02 1 3.391035970e-02 1 3.391036970e-02 0 3.391072478e-02 0 3.391073478e-02 1 3.393569789e-02 1
+ 3.393570789e-02 0 3.393606276e-02 0 3.393607276e-02 1 3.396103618e-02 1 3.396104618e-02 0 3.396140072e-02 0 3.396141072e-02 1 3.398637431e-02 1
+ 3.398638431e-02 0 3.398673889e-02 0 3.398674889e-02 1 3.401171232e-02 1 3.401172232e-02 0 3.401207713e-02 0 3.401208713e-02 1 3.403705023e-02 1
+ 3.403706023e-02 0 3.403741539e-02 0 3.403742539e-02 1 3.406238839e-02 1 3.406239839e-02 0 3.406275337e-02 0 3.406276337e-02 1 3.408772659e-02 1
+ 3.408773659e-02 0 3.408809137e-02 0 3.408810137e-02 1 3.411306494e-02 1 3.411307494e-02 0 3.411342930e-02 0 3.411343930e-02 1 3.413840288e-02 1
+ 3.413841288e-02 0 3.413876766e-02 0 3.413877766e-02 1 3.416374098e-02 1 3.416375098e-02 0 3.416410578e-02 0 3.416411578e-02 1 3.418907873e-02 1
+ 3.418908873e-02 0 3.418944417e-02 0 3.418945417e-02 1 3.421441724e-02 1 3.421442724e-02 0 3.421478181e-02 0 3.421479181e-02 1 3.422500200e-02 1
+ 3.422501200e-02 0 3.706666867e-02 0 3.706716867e-02 1 3.709166341e-02 1 3.709167341e-02 0 3.709205846e-02 0 3.709206846e-02 1 3.711700252e-02 1
+ 3.711701252e-02 0 3.711736749e-02 0 3.711737749e-02 1 3.714234078e-02 1 3.714235078e-02 0 3.714270545e-02 0 3.714271545e-02 1 3.716767898e-02 1
+ 3.716768898e-02 0 3.716804353e-02 0 3.716805353e-02 1 3.719301704e-02 1 3.719302704e-02 0 3.719338174e-02 0 3.719339174e-02 1 3.721835499e-02 1
+ 3.721836499e-02 0 3.721872000e-02 0 3.721873000e-02 1 3.724369303e-02 1 3.724370303e-02 0 3.724405811e-02 0 3.724406811e-02 1 3.726903122e-02 1
+ 3.726904122e-02 0 3.726939609e-02 0 3.726940609e-02 1 3.729436951e-02 1 3.729437951e-02 0 3.729473405e-02 0 3.729474405e-02 1 3.731970764e-02 1
+ 3.731971764e-02 0 3.732007222e-02 0 3.732008222e-02 1 3.734504565e-02 1 3.734505565e-02 0 3.734541046e-02 0 3.734542046e-02 1 3.737038356e-02 1
+ 3.737039356e-02 0 3.737074873e-02 0 3.737075873e-02 1 3.739572173e-02 1 3.739573173e-02 0 3.739608670e-02 0 3.739609670e-02 1 3.742105992e-02 1
+ 3.742106992e-02 0 3.742142471e-02 0 3.742143471e-02 1 3.744639828e-02 1 3.744640828e-02 0 3.744676263e-02 0 3.744677263e-02 1 3.747173621e-02 1
+ 3.747174621e-02 0 3.747210100e-02 0 3.747211100e-02 1 3.749707431e-02 1 3.749708431e-02 0 3.749743911e-02 0 3.749744911e-02 1 3.752241207e-02 1
+ 3.752242207e-02 0 3.752277750e-02 0 3.752278750e-02 1 3.754775057e-02 1 3.754776057e-02 0 3.754811514e-02 0 3.754812514e-02 1 3.755833533e-02 1
+ 3.755834533e-02 0 4.040000200e-02 0 4.040050200e-02 1 4.042499675e-02 1 4.042500675e-02 0 4.042539180e-02 0 4.042540180e-02 1 4.045033586e-02 1
+ 4.045034586e-02 0 4.045070083e-02 0 4.045071083e-02 1 4.047567411e-02 1 4.047568411e-02 0 4.047603879e-02 0 4.047604879e-02 1 4.050101232e-02 1
+ 4.050102232e-02 0 4.050137686e-02 0 4.050138686e-02 1 4.052635038e-02 1 4.052636038e-02 0 4.052671508e-02 0 4.052672508e-02 1 4.055168833e-02 1
+ 4.055169833e-02 0 4.055205334e-02 0 4.055206334e-02 1 4.057702637e-02 1 4.057703637e-02 0 4.057739145e-02 0 4.057740145e-02 1 4.060236456e-02 1
+ 4.060237456e-02 0 4.060272943e-02 0 4.060273943e-02 1 4.062770285e-02 1 4.062771285e-02 0 4.062806739e-02 0 4.062807739e-02 1 4.065304098e-02 1
+ 4.065305098e-02 0 4.065340556e-02 0 4.065341556e-02 1 4.067837899e-02 1 4.067838899e-02 0 4.067874380e-02 0 4.067875380e-02 1 4.070371690e-02 1
+ 4.070372690e-02 0 4.070408206e-02 0 4.070409206e-02 1 4.072905506e-02 1 4.072906506e-02 0 4.072942004e-02 0 4.072943004e-02 1 4.075439326e-02 1
+ 4.075440326e-02 0 4.075475804e-02 0 4.075476804e-02 1 4.077973161e-02 1 4.077974161e-02 0 4.078009597e-02 0 4.078010597e-02 1 4.080506955e-02 1
+ 4.080507955e-02 0 4.080543433e-02 0 4.080544433e-02 1 4.083040765e-02 1 4.083041765e-02 0 4.083077245e-02 0 4.083078245e-02 1 4.085574541e-02 1
+ 4.085575541e-02 0 4.085611083e-02 0 4.085612083e-02 1 4.088108391e-02 1 4.088109391e-02 0 4.088144848e-02 0 4.088145848e-02 1 4.089166867e-02 1
+ 4.089167867e-02 0 4.433333333e-02 0)
V_mf_sg3a1 mf_sg3a1 0 PWL(0.000000000e+00 0 4.249969231e-04 0 4.250069231e-04 1 4.253419920e-04 1 4.253519920e-04 0 4.756743563e-04 0 4.756843563e-04 1 4.760189275e-04 1
+ 4.760289275e-04 0 5.263505210e-04 0 5.263605210e-04 1 5.266953113e-04 1 5.267053113e-04 0 5.770265785e-04 0 5.770365785e-04 1 5.773715778e-04 1
+ 5.773815778e-04 0 6.277031057e-04 0 6.277131057e-04 1 6.280475213e-04 1 6.280575213e-04 0 6.783791576e-04 0 6.783891576e-04 1 6.787239889e-04 1
+ 6.787339889e-04 0 7.290553738e-04 0 7.290653738e-04 1 7.294000694e-04 1 7.294100694e-04 0 7.797319657e-04 0 7.797419657e-04 1 7.800760146e-04 1
+ 7.800860146e-04 0 8.304080237e-04 0 8.304180237e-04 1 8.307524168e-04 1 8.307624168e-04 0 8.550617561e-04 0 8.550717561e-04 1 8.554052399e-04 1
+ 8.554152399e-04 0 8.797148363e-04 0 8.797248363e-04 1 8.800586831e-04 1 8.800686831e-04 0 3.758330069e-03 0 3.758340069e-03 1 3.758675138e-03 1
+ 3.758685138e-03 0 3.809007442e-03 0 3.809017442e-03 1 3.809352112e-03 1 3.809362112e-03 0 3.859683703e-03 0 3.859693703e-03 1 3.860028406e-03 1
+ 3.860038406e-03 0 3.910359693e-03 0 3.910369693e-03 1 3.910704771e-03 1 3.910714771e-03 0 3.961036180e-03 0 3.961046180e-03 1 3.961380707e-03 1
+ 3.961390707e-03 0 4.011712314e-03 0 4.011722314e-03 1 4.012057123e-03 1 4.012067123e-03 0 4.062388391e-03 0 4.062398391e-03 1 4.062733356e-03 1
+ 4.062743356e-03 0 4.113064947e-03 0 4.113074947e-03 1 4.113409287e-03 1 4.113419287e-03 0 4.163740977e-03 0 4.163750977e-03 1 4.164085770e-03 1
+ 4.164095770e-03 0 4.214417255e-03 0 4.214427255e-03 1 4.214761780e-03 1 4.214771780e-03 0 7.091663426e-03 0 7.091673426e-03 1 7.092008487e-03 1
+ 7.092018487e-03 0 7.142340792e-03 0 7.142350792e-03 1 7.142685469e-03 1 7.142695469e-03 0 7.193017056e-03 0 7.193027056e-03 1 7.193361758e-03 1
+ 7.193371758e-03 0 7.243693050e-03 0 7.243703050e-03 1 7.244038123e-03 1 7.244048123e-03 0 7.294369528e-03 0 7.294379528e-03 1 7.294714066e-03 1
+ 7.294724066e-03 0 7.345045668e-03 0 7.345055668e-03 1 7.345390474e-03 1 7.345400474e-03 0 7.395721743e-03 0 7.395731743e-03 1 7.396066713e-03 1
+ 7.396076713e-03 0 7.446398290e-03 0 7.446408290e-03 1 7.446742651e-03 1 7.446752651e-03 0 7.497074325e-03 0 7.497084325e-03 1 7.497419128e-03 1
+ 7.497429128e-03 0 7.547750590e-03 0 7.547760590e-03 1 7.548095153e-03 1 7.548105153e-03 0 1.042499675e-02 0 1.042500675e-02 1 1.042534181e-02 1
+ 1.042535181e-02 0 1.047567412e-02 0 1.047568412e-02 1 1.047601880e-02 1 1.047602880e-02 0 1.052635038e-02 0 1.052636038e-02 1 1.052669508e-02 1
+ 1.052670508e-02 0 1.057702638e-02 0 1.057703638e-02 1 1.057737145e-02 1 1.057738145e-02 0 1.062770285e-02 0 1.062771285e-02 1 1.062804739e-02 1
+ 1.062805739e-02 0 1.067837899e-02 0 1.067838899e-02 1 1.067872380e-02 1 1.067873380e-02 0 1.072905507e-02 0 1.072906507e-02 1 1.072940004e-02 1
+ 1.072941004e-02 0 1.077973162e-02 0 1.077974162e-02 1 1.078007598e-02 1 1.078008598e-02 0 1.083040765e-02 0 1.083041765e-02 1 1.083075246e-02 1
+ 1.083076246e-02 0 1.088108391e-02 0 1.088109391e-02 1 1.088142848e-02 1 1.088143848e-02 0 1.375833008e-02 0 1.375834008e-02 1 1.375867515e-02 1
+ 1.375868515e-02 0 1.380900745e-02 0 1.380901745e-02 1 1.380935213e-02 1 1.380936213e-02 0 1.385968371e-02 0 1.385969371e-02 1 1.386002841e-02 1
+ 1.386003841e-02 0 1.391035971e-02 0 1.391036971e-02 1 1.391070478e-02 1 1.391071478e-02 0 1.396103619e-02 0 1.396104619e-02 1 1.396138072e-02 1
+ 1.396139072e-02 0 1.401171233e-02 0 1.401172233e-02 1 1.401205713e-02 1 1.401206713e-02 0 1.406238840e-02 0 1.406239840e-02 1 1.406273337e-02 1
+ 1.406274337e-02 0 1.411306495e-02 0 1.411307495e-02 1 1.411340931e-02 1 1.411341931e-02 0 1.416374098e-02 0 1.416375098e-02 1 1.416408579e-02 1
+ 1.416409579e-02 0 1.421441724e-02 0 1.421442724e-02 1 1.421476181e-02 1 1.421477181e-02 0 1.709166341e-02 0 1.709167341e-02 1 1.709200848e-02 1
+ 1.709201848e-02 0 1.714234078e-02 0 1.714235078e-02 1 1.714268546e-02 1 1.714269546e-02 0 1.719301705e-02 0 1.719302705e-02 1 1.719336175e-02 1
+ 1.719337175e-02 0 1.724369304e-02 0 1.724370304e-02 1 1.724403811e-02 1 1.724404811e-02 0 1.729436952e-02 0 1.729437952e-02 1 1.729471405e-02 1
+ 1.729472405e-02 0 1.734504566e-02 0 1.734505566e-02 1 1.734539046e-02 1 1.734540046e-02 0 1.739572173e-02 0 1.739573173e-02 1 1.739606670e-02 1
+ 1.739607670e-02 0 1.744639828e-02 0 1.744640828e-02 1 1.744674264e-02 1 1.744675264e-02 0 1.749707431e-02 0 1.749708431e-02 1 1.749741912e-02 1
+ 1.749742912e-02 0 1.754775057e-02 0 1.754776057e-02 1 1.754809515e-02 1 1.754810515e-02 0 2.042499674e-02 0 2.042500674e-02 1 2.042534181e-02 1
+ 2.042535181e-02 0 2.047567411e-02 0 2.047568411e-02 1 2.047601879e-02 1 2.047602879e-02 0 2.052635038e-02 0 2.052636038e-02 1 2.052669507e-02 1
+ 2.052670507e-02 0 2.057702636e-02 0 2.057703636e-02 1 2.057737144e-02 1 2.057738144e-02 0 2.062770285e-02 0 2.062771285e-02 1 2.062804738e-02 1
+ 2.062805738e-02 0 2.067837899e-02 0 2.067838899e-02 1 2.067872379e-02 1 2.067873379e-02 0 2.072905506e-02 0 2.072906506e-02 1 2.072940003e-02 1
+ 2.072941003e-02 0 2.077973161e-02 0 2.077974161e-02 1 2.078007597e-02 1 2.078008597e-02 0 2.083040764e-02 0 2.083041764e-02 1 2.083075245e-02 1
+ 2.083076245e-02 0 2.088108390e-02 0 2.088109390e-02 1 2.088142847e-02 1 2.088143847e-02 0 2.375833007e-02 0 2.375834007e-02 1 2.375867514e-02 1
+ 2.375868514e-02 0 2.380900744e-02 0 2.380901744e-02 1 2.380935212e-02 1 2.380936212e-02 0 2.385968371e-02 0 2.385969371e-02 1 2.386002840e-02 1
+ 2.386003840e-02 0 2.391035970e-02 0 2.391036970e-02 1 2.391070477e-02 1 2.391071477e-02 0 2.396103618e-02 0 2.396104618e-02 1 2.396138071e-02 1
+ 2.396139071e-02 0 2.401171232e-02 0 2.401172232e-02 1 2.401205712e-02 1 2.401206712e-02 0 2.406238839e-02 0 2.406239839e-02 1 2.406273336e-02 1
+ 2.406274336e-02 0 2.411306494e-02 0 2.411307494e-02 1 2.411340930e-02 1 2.411341930e-02 0 2.416374097e-02 0 2.416375097e-02 1 2.416408578e-02 1
+ 2.416409578e-02 0 2.421441723e-02 0 2.421442723e-02 1 2.421476181e-02 1 2.421477181e-02 0 2.709166341e-02 0 2.709167341e-02 1 2.709200847e-02 1
+ 2.709201847e-02 0 2.714234078e-02 0 2.714235078e-02 1 2.714268545e-02 1 2.714269545e-02 0 2.719301704e-02 0 2.719302704e-02 1 2.719336174e-02 1
+ 2.719337174e-02 0 2.724369303e-02 0 2.724370303e-02 1 2.724403811e-02 1 2.724404811e-02 0 2.729436951e-02 0 2.729437951e-02 1 2.729471405e-02 1
+ 2.729472405e-02 0 2.734504565e-02 0 2.734505565e-02 1 2.734539046e-02 1 2.734540046e-02 0 2.739572173e-02 0 2.739573173e-02 1 2.739606670e-02 1
+ 2.739607670e-02 0 2.744639827e-02 0 2.744640827e-02 1 2.744674263e-02 1 2.744675263e-02 0 2.749707431e-02 0 2.749708431e-02 1 2.749741911e-02 1
+ 2.749742911e-02 0 2.754775057e-02 0 2.754776057e-02 1 2.754809514e-02 1 2.754810514e-02 0 3.042499675e-02 0 3.042500675e-02 1 3.042534181e-02 1
+ 3.042535181e-02 0 3.047567412e-02 0 3.047568412e-02 1 3.047601880e-02 1 3.047602880e-02 0 3.052635038e-02 0 3.052636038e-02 1 3.052669508e-02 1
+ 3.052670508e-02 0 3.057702638e-02 0 3.057703638e-02 1 3.057737145e-02 1 3.057738145e-02 0 3.062770285e-02 0 3.062771285e-02 1 3.062804739e-02 1
+ 3.062805739e-02 0 3.067837899e-02 0 3.067838899e-02 1 3.067872380e-02 1 3.067873380e-02 0 3.072905507e-02 0 3.072906507e-02 1 3.072940004e-02 1
+ 3.072941004e-02 0 3.077973162e-02 0 3.077974162e-02 1 3.078007598e-02 1 3.078008598e-02 0 3.083040765e-02 0 3.083041765e-02 1 3.083075246e-02 1
+ 3.083076246e-02 0 3.088108391e-02 0 3.088109391e-02 1 3.088142848e-02 1 3.088143848e-02 0 3.375833008e-02 0 3.375834008e-02 1 3.375867514e-02 1
+ 3.375868514e-02 0 3.380900744e-02 0 3.380901744e-02 1 3.380935212e-02 1 3.380936212e-02 0 3.385968371e-02 0 3.385969371e-02 1 3.386002841e-02 1
+ 3.386003841e-02 0 3.391035970e-02 0 3.391036970e-02 1 3.391070478e-02 1 3.391071478e-02 0 3.396103618e-02 0 3.396104618e-02 1 3.396138072e-02 1
+ 3.396139072e-02 0 3.401171232e-02 0 3.401172232e-02 1 3.401205713e-02 1 3.401206713e-02 0 3.406238839e-02 0 3.406239839e-02 1 3.406273337e-02 1
+ 3.406274337e-02 0 3.411306494e-02 0 3.411307494e-02 1 3.411340930e-02 1 3.411341930e-02 0 3.416374098e-02 0 3.416375098e-02 1 3.416408578e-02 1
+ 3.416409578e-02 0 3.421441724e-02 0 3.421442724e-02 1 3.421476181e-02 1 3.421477181e-02 0 3.709166341e-02 0 3.709167341e-02 1 3.709200847e-02 1
+ 3.709201847e-02 0 3.714234078e-02 0 3.714235078e-02 1 3.714268545e-02 1 3.714269545e-02 0 3.719301704e-02 0 3.719302704e-02 1 3.719336174e-02 1
+ 3.719337174e-02 0 3.724369303e-02 0 3.724370303e-02 1 3.724403811e-02 1 3.724404811e-02 0 3.729436951e-02 0 3.729437951e-02 1 3.729471405e-02 1
+ 3.729472405e-02 0 3.734504565e-02 0 3.734505565e-02 1 3.734539046e-02 1 3.734540046e-02 0 3.739572173e-02 0 3.739573173e-02 1 3.739606670e-02 1
+ 3.739607670e-02 0 3.744639828e-02 0 3.744640828e-02 1 3.744674263e-02 1 3.744675263e-02 0 3.749707431e-02 0 3.749708431e-02 1 3.749741911e-02 1
+ 3.749742911e-02 0 3.754775057e-02 0 3.754776057e-02 1 3.754809514e-02 1 3.754810514e-02 0 4.042499675e-02 0 4.042500675e-02 1 4.042534181e-02 1
+ 4.042535181e-02 0 4.047567411e-02 0 4.047568411e-02 1 4.047601879e-02 1 4.047602879e-02 0 4.052635038e-02 0 4.052636038e-02 1 4.052669508e-02 1
+ 4.052670508e-02 0 4.057702637e-02 0 4.057703637e-02 1 4.057737145e-02 1 4.057738145e-02 0 4.062770285e-02 0 4.062771285e-02 1 4.062804739e-02 1
+ 4.062805739e-02 0 4.067837899e-02 0 4.067838899e-02 1 4.067872380e-02 1 4.067873380e-02 0 4.072905506e-02 0 4.072906506e-02 1 4.072940004e-02 1
+ 4.072941004e-02 0 4.077973161e-02 0 4.077974161e-02 1 4.078007597e-02 1 4.078008597e-02 0 4.083040765e-02 0 4.083041765e-02 1 4.083075245e-02 1
+ 4.083076245e-02 0 4.088108391e-02 0 4.088109391e-02 1 4.088142848e-02 1 4.088143848e-02 0 4.433333333e-02 0)
V_mr_sg3a1 mr_sg3a1 0 PWL(0.000000000e+00 0 4.503360784e-04 0 4.503460784e-04 1 4.506809642e-04 1 4.506909642e-04 0 5.010125012e-04 0 5.010225012e-04 1 5.013570732e-04 1
+ 5.013670732e-04 0 5.516884442e-04 0 5.516984442e-04 1 5.520335678e-04 1 5.520435678e-04 0 6.023647796e-04 0 6.023747796e-04 1 6.027095720e-04 1
+ 6.027195720e-04 0 6.530410964e-04 0 6.530510964e-04 1 6.533858255e-04 1 6.533958255e-04 0 7.037169799e-04 0 7.037269799e-04 1 7.040623152e-04 1
+ 7.040723152e-04 0 7.543933927e-04 0 7.544033927e-04 1 7.547382864e-04 1 7.547482864e-04 0 8.050694723e-04 0 8.050794723e-04 1 8.054147887e-04 1
+ 8.054247887e-04 0 8.916686667e-04 0 8.916786667e-04 1 8.917019300e-04 1 8.922019300e-04 0 3.783669185e-03 0 3.783679185e-03 1 3.784014154e-03 1
+ 3.784024154e-03 0 3.834345647e-03 0 3.834355647e-03 1 3.834690187e-03 1 3.834700187e-03 0 3.885021645e-03 0 3.885031645e-03 1 3.885366670e-03 1
+ 3.885376670e-03 0 3.935697885e-03 0 3.935707885e-03 1 3.936042751e-03 1 3.936052751e-03 0 3.986374301e-03 0 3.986384301e-03 1 3.986718882e-03 1
+ 3.986728882e-03 0 4.037050215e-03 0 4.037060215e-03 1 4.037395392e-03 1 4.037405392e-03 0 4.087726580e-03 0 4.087736580e-03 1 4.088071369e-03 1
+ 4.088081369e-03 0 4.138402861e-03 0 4.138412861e-03 1 4.138747670e-03 1 4.138757670e-03 0 4.189078711e-03 0 4.189088711e-03 1 4.189424176e-03 1
+ 4.189434176e-03 0 4.225002000e-03 0 4.225012000e-03 1 4.225034521e-03 1 4.225534521e-03 0 7.117002540e-03 0 7.117012540e-03 1 7.117347507e-03 1
+ 7.117357507e-03 0 7.167678997e-03 0 7.167688997e-03 1 7.168023543e-03 1 7.168033543e-03 0 7.218355003e-03 0 7.218365003e-03 1 7.218700019e-03 1
+ 7.218710019e-03 0 7.269031239e-03 0 7.269041239e-03 1 7.269376107e-03 1 7.269386107e-03 0 7.319707653e-03 0 7.319717653e-03 1 7.320052235e-03 1
+ 7.320062235e-03 0 7.370383576e-03 0 7.370393576e-03 1 7.370728739e-03 1 7.370738739e-03 0 7.421059935e-03 0 7.421069935e-03 1 7.421404723e-03 1
+ 7.421414723e-03 0 7.471736221e-03 0 7.471746221e-03 1 7.472081015e-03 1 7.472091015e-03 0 7.522412083e-03 0 7.522422083e-03 1 7.522757512e-03 1
+ 7.522767512e-03 0 7.558335333e-03 0 7.558345333e-03 1 7.558367849e-03 1 7.558867849e-03 0 1.045033587e-02 0 1.045034587e-02 1 1.045068083e-02 1
+ 1.045069083e-02 0 1.050101232e-02 0 1.050102232e-02 1 1.050135687e-02 1 1.050136687e-02 0 1.055168833e-02 0 1.055169833e-02 1 1.055203335e-02 1
+ 1.055204335e-02 0 1.060236456e-02 0 1.060237456e-02 1 1.060270943e-02 1 1.060271943e-02 0 1.065304098e-02 0 1.065305098e-02 1 1.065338556e-02 1
+ 1.065339556e-02 0 1.070371690e-02 0 1.070372690e-02 1 1.070406207e-02 1 1.070407207e-02 0 1.075439326e-02 0 1.075440326e-02 1 1.075473805e-02 1
+ 1.075474805e-02 0 1.080506955e-02 0 1.080507955e-02 1 1.080541434e-02 1 1.080542434e-02 0 1.085574541e-02 0 1.085575541e-02 1 1.085609084e-02 1
+ 1.085610084e-02 0 1.089166867e-02 0 1.089167867e-02 1 1.089170117e-02 1 1.089220117e-02 0 1.378366920e-02 0 1.378367920e-02 1 1.378401417e-02 1
+ 1.378402417e-02 0 1.383434566e-02 0 1.383435566e-02 1 1.383469020e-02 1 1.383470020e-02 0 1.388502166e-02 0 1.388503166e-02 1 1.388536668e-02 1
+ 1.388537668e-02 0 1.393569790e-02 0 1.393570790e-02 1 1.393604277e-02 1 1.393605277e-02 0 1.398637431e-02 0 1.398638431e-02 1 1.398671889e-02 1
+ 1.398672889e-02 0 1.403705023e-02 0 1.403706023e-02 1 1.403739540e-02 1 1.403740540e-02 0 1.408772659e-02 0 1.408773659e-02 1 1.408807138e-02 1
+ 1.408808138e-02 0 1.413840288e-02 0 1.413841288e-02 1 1.413874767e-02 1 1.413875767e-02 0 1.418907874e-02 0 1.418908874e-02 1 1.418942417e-02 1
+ 1.418943417e-02 0 1.422500200e-02 0 1.422501200e-02 1 1.422503450e-02 1 1.422553450e-02 0 1.711700253e-02 0 1.711701253e-02 1 1.711734750e-02 1
+ 1.711735750e-02 0 1.716767899e-02 0 1.716768899e-02 1 1.716802353e-02 1 1.716803353e-02 0 1.721835499e-02 0 1.721836499e-02 1 1.721870001e-02 1
+ 1.721871001e-02 0 1.726903123e-02 0 1.726904123e-02 1 1.726937610e-02 1 1.726938610e-02 0 1.731970764e-02 0 1.731971764e-02 1 1.732005222e-02 1
+ 1.732006222e-02 0 1.737038356e-02 0 1.737039356e-02 1 1.737072873e-02 1 1.737073873e-02 0 1.742105992e-02 0 1.742106992e-02 1 1.742140471e-02 1
+ 1.742141471e-02 0 1.747173621e-02 0 1.747174621e-02 1 1.747208100e-02 1 1.747209100e-02 0 1.752241207e-02 0 1.752242207e-02 1 1.752275750e-02 1
+ 1.752276750e-02 0 1.755833533e-02 0 1.755834533e-02 1 1.755836783e-02 1 1.755886783e-02 0 2.045033585e-02 0 2.045034585e-02 1 2.045068083e-02 1
+ 2.045069083e-02 0 2.050101232e-02 0 2.050102232e-02 1 2.050135686e-02 1 2.050136686e-02 0 2.055168832e-02 0 2.055169832e-02 1 2.055203334e-02 1
+ 2.055204334e-02 0 2.060236455e-02 0 2.060237455e-02 1 2.060270942e-02 1 2.060271942e-02 0 2.065304097e-02 0 2.065305097e-02 1 2.065338555e-02 1
+ 2.065339555e-02 0 2.070371689e-02 0 2.070372689e-02 1 2.070406206e-02 1 2.070407206e-02 0 2.075439325e-02 0 2.075440325e-02 1 2.075473804e-02 1
+ 2.075474804e-02 0 2.080506954e-02 0 2.080507954e-02 1 2.080541433e-02 1 2.080542433e-02 0 2.085574540e-02 0 2.085575540e-02 1 2.085609083e-02 1
+ 2.085610083e-02 0 2.089166867e-02 0 2.089167867e-02 1 2.089170116e-02 1 2.089220116e-02 0 2.378366919e-02 0 2.378367919e-02 1 2.378401416e-02 1
+ 2.378402416e-02 0 2.383434565e-02 0 2.383435565e-02 1 2.383469019e-02 1 2.383470019e-02 0 2.388502165e-02 0 2.388503165e-02 1 2.388536667e-02 1
+ 2.388537667e-02 0 2.393569788e-02 0 2.393570788e-02 1 2.393604276e-02 1 2.393605276e-02 0 2.398637430e-02 0 2.398638430e-02 1 2.398671888e-02 1
+ 2.398672888e-02 0 2.403705022e-02 0 2.403706022e-02 1 2.403739539e-02 1 2.403740539e-02 0 2.408772658e-02 0 2.408773658e-02 1 2.408807137e-02 1
+ 2.408808137e-02 0 2.413840287e-02 0 2.413841287e-02 1 2.413874766e-02 1 2.413875766e-02 0 2.418907873e-02 0 2.418908873e-02 1 2.418942416e-02 1
+ 2.418943416e-02 0 2.422500200e-02 0 2.422501200e-02 1 2.422503449e-02 1 2.422553449e-02 0 2.711700252e-02 0 2.711701252e-02 1 2.711734749e-02 1
+ 2.711735749e-02 0 2.716767898e-02 0 2.716768898e-02 1 2.716802353e-02 1 2.716803353e-02 0 2.721835499e-02 0 2.721836499e-02 1 2.721870000e-02 1
+ 2.721871000e-02 0 2.726903122e-02 0 2.726904122e-02 1 2.726937609e-02 1 2.726938609e-02 0 2.731970764e-02 0 2.731971764e-02 1 2.732005222e-02 1
+ 2.732006222e-02 0 2.737038356e-02 0 2.737039356e-02 1 2.737072872e-02 1 2.737073872e-02 0 2.742105992e-02 0 2.742106992e-02 1 2.742140471e-02 1
+ 2.742141471e-02 0 2.747173621e-02 0 2.747174621e-02 1 2.747208100e-02 1 2.747209100e-02 0 2.752241207e-02 0 2.752242207e-02 1 2.752275750e-02 1
+ 2.752276750e-02 0 2.755833533e-02 0 2.755834533e-02 1 2.755836783e-02 1 2.755886783e-02 0 3.045033587e-02 0 3.045034587e-02 1 3.045068083e-02 1
+ 3.045069083e-02 0 3.050101232e-02 0 3.050102232e-02 1 3.050135687e-02 1 3.050136687e-02 0 3.055168833e-02 0 3.055169833e-02 1 3.055203334e-02 1
+ 3.055204334e-02 0 3.060236456e-02 0 3.060237456e-02 1 3.060270943e-02 1 3.060271943e-02 0 3.065304098e-02 0 3.065305098e-02 1 3.065338556e-02 1
+ 3.065339556e-02 0 3.070371690e-02 0 3.070372690e-02 1 3.070406207e-02 1 3.070407207e-02 0 3.075439326e-02 0 3.075440326e-02 1 3.075473805e-02 1
+ 3.075474805e-02 0 3.080506955e-02 0 3.080507955e-02 1 3.080541434e-02 1 3.080542434e-02 0 3.085574541e-02 0 3.085575541e-02 1 3.085609084e-02 1
+ 3.085610084e-02 0 3.089166867e-02 0 3.089167867e-02 1 3.089170117e-02 1 3.089220117e-02 0 3.378366919e-02 0 3.378367919e-02 1 3.378401416e-02 1
+ 3.378402416e-02 0 3.383434565e-02 0 3.383435565e-02 1 3.383469019e-02 1 3.383470019e-02 0 3.388502166e-02 0 3.388503166e-02 1 3.388536667e-02 1
+ 3.388537667e-02 0 3.393569789e-02 0 3.393570789e-02 1 3.393604276e-02 1 3.393605276e-02 0 3.398637431e-02 0 3.398638431e-02 1 3.398671889e-02 1
+ 3.398672889e-02 0 3.403705023e-02 0 3.403706023e-02 1 3.403739539e-02 1 3.403740539e-02 0 3.408772659e-02 0 3.408773659e-02 1 3.408807137e-02 1
+ 3.408808137e-02 0 3.413840288e-02 0 3.413841288e-02 1 3.413874766e-02 1 3.413875766e-02 0 3.418907873e-02 0 3.418908873e-02 1 3.418942417e-02 1
+ 3.418943417e-02 0 3.422500200e-02 0 3.422501200e-02 1 3.422503450e-02 1 3.422553450e-02 0 3.711700252e-02 0 3.711701252e-02 1 3.711734749e-02 1
+ 3.711735749e-02 0 3.716767898e-02 0 3.716768898e-02 1 3.716802353e-02 1 3.716803353e-02 0 3.721835499e-02 0 3.721836499e-02 1 3.721870000e-02 1
+ 3.721871000e-02 0 3.726903122e-02 0 3.726904122e-02 1 3.726937609e-02 1 3.726938609e-02 0 3.731970764e-02 0 3.731971764e-02 1 3.732005222e-02 1
+ 3.732006222e-02 0 3.737038356e-02 0 3.737039356e-02 1 3.737072873e-02 1 3.737073873e-02 0 3.742105992e-02 0 3.742106992e-02 1 3.742140471e-02 1
+ 3.742141471e-02 0 3.747173621e-02 0 3.747174621e-02 1 3.747208100e-02 1 3.747209100e-02 0 3.752241207e-02 0 3.752242207e-02 1 3.752275750e-02 1
+ 3.752276750e-02 0 3.755833533e-02 0 3.755834533e-02 1 3.755836783e-02 1 3.755886783e-02 0 4.045033586e-02 0 4.045034586e-02 1 4.045068083e-02 1
+ 4.045069083e-02 0 4.050101232e-02 0 4.050102232e-02 1 4.050135686e-02 1 4.050136686e-02 0 4.055168833e-02 0 4.055169833e-02 1 4.055203334e-02 1
+ 4.055204334e-02 0 4.060236456e-02 0 4.060237456e-02 1 4.060270943e-02 1 4.060271943e-02 0 4.065304098e-02 0 4.065305098e-02 1 4.065338556e-02 1
+ 4.065339556e-02 0 4.070371690e-02 0 4.070372690e-02 1 4.070406206e-02 1 4.070407206e-02 0 4.075439326e-02 0 4.075440326e-02 1 4.075473804e-02 1
+ 4.075474804e-02 0 4.080506955e-02 0 4.080507955e-02 1 4.080541433e-02 1 4.080542433e-02 0 4.085574541e-02 0 4.085575541e-02 1 4.085609083e-02 1
+ 4.085610083e-02 0 4.089166867e-02 0 4.089167867e-02 1 4.089170117e-02 1 4.089220117e-02 0 4.433333333e-02 0)
V_sSG3b1 7 s_sg3b1 0
XSG3b1 s_sg3b1 3 mbi_sg3b1 mf_sg3b1 mr_sg3b1 ia2_gap
V_mbi_sg3b1 mbi_sg3b1 0 PWL(0.000000000e+00 0 8.916686667e-04 0 8.921686667e-04 1 1.500002000e-03 1 1.500502000e-03 0 4.225002000e-03 0 4.225502000e-03 1 4.833335333e-03 1
+ 4.833835333e-03 0 7.558335333e-03 0 7.558835333e-03 1 8.166668667e-03 1 8.167168667e-03 0 1.089166867e-02 0 1.089216867e-02 1 1.150000200e-02 1
+ 1.150050200e-02 0 1.422500200e-02 0 1.422550200e-02 1 1.483333533e-02 1 1.483383533e-02 0 1.755833533e-02 0 1.755883533e-02 1 1.816666867e-02 1
+ 1.816716867e-02 0 2.089166867e-02 0 2.089216867e-02 1 2.150000200e-02 1 2.150050200e-02 0 2.422500200e-02 0 2.422550200e-02 1 2.483333533e-02 1
+ 2.483383533e-02 0 2.755833533e-02 0 2.755883533e-02 1 2.816666867e-02 1 2.816716867e-02 0 3.089166867e-02 0 3.089216867e-02 1 3.150000200e-02 1
+ 3.150050200e-02 0 3.422500200e-02 0 3.422550200e-02 1 3.483333533e-02 1 3.483383533e-02 0 3.755833533e-02 0 3.755883533e-02 1 3.816666867e-02 1
+ 3.816716867e-02 0 4.089166867e-02 0 4.089216867e-02 1 4.150000200e-02 1 4.150050200e-02 0 4.433333333e-02 0)
V_mf_sg3b1 mf_sg3b1 0 PWL(0.000000000e+00 0 4.433333333e-02 0)
V_mr_sg3b1 mr_sg3b1 0 PWL(0.000000000e+00 0 4.433333333e-02 0)
V_sSG4a1 4 s_sg4a1 0
XSG4a1 s_sg4a1 8 mbi_sg4a1 mf_sg4a1 mr_sg4a1 ia2_gap
V_mbi_sg4a1 mbi_sg4a1 0 PWL(0.000000000e+00 0 2.066668667e-03 0 2.067168667e-03 1 2.091663425e-03 1 2.091673425e-03 0 2.092058437e-03 0 2.092068437e-03 1 2.117002552e-03 1
+ 2.117012552e-03 0 2.117367502e-03 0 2.117377502e-03 1 2.142340817e-03 1 2.142350817e-03 0 2.142705459e-03 0 2.142715459e-03 1 2.167679011e-03 1
+ 2.167689011e-03 0 2.168043549e-03 0 2.168053549e-03 1 2.193017054e-03 1 2.193027054e-03 0 2.193381779e-03 0 2.193391779e-03 1 2.218354990e-03 1
+ 2.218364990e-03 0 2.218720041e-03 0 2.218730041e-03 1 2.243693054e-03 1 2.243703054e-03 0 2.244058124e-03 0 2.244068124e-03 1 2.269031256e-03 1
+ 2.269041256e-03 0 2.269396098e-03 0 2.269406098e-03 1 2.294369556e-03 1 2.294379556e-03 0 2.294734056e-03 0 2.294744056e-03 1 2.319707654e-03 1
+ 2.319717654e-03 0 2.320072256e-03 0 2.320082256e-03 1 2.345045664e-03 1 2.345055664e-03 0 2.345410493e-03 0 2.345420493e-03 1 2.370383556e-03 1
+ 2.370393556e-03 0 2.370748764e-03 0 2.370758764e-03 1 2.395721767e-03 1 2.395731767e-03 0 2.396086693e-03 0 2.396096693e-03 1 2.421059944e-03 1
+ 2.421069944e-03 0 2.421424726e-03 0 2.421434726e-03 1 2.446398332e-03 1 2.446408332e-03 0 2.446762630e-03 0 2.446772630e-03 1 2.471736188e-03 1
+ 2.471746188e-03 0 2.472101068e-03 0 2.472111068e-03 1 2.497074349e-03 1 2.497084349e-03 0 2.497439114e-03 0 2.497449114e-03 1 2.522412028e-03 1
+ 2.522422028e-03 0 2.522777570e-03 0 2.522787570e-03 1 2.547750680e-03 1 2.547760680e-03 0 2.548115070e-03 0 2.548125070e-03 1 2.558335333e-03 1
+ 2.558345333e-03 0 5.400002000e-03 0 5.400502000e-03 1 5.424996755e-03 1 5.425006755e-03 0 5.425391798e-03 0 5.425401798e-03 1 5.450335870e-03 1
+ 5.450345870e-03 0 5.450700837e-03 0 5.450710837e-03 1 5.475674124e-03 1 5.475684124e-03 0 5.476038798e-03 0 5.476048798e-03 1 5.501012328e-03 1
+ 5.501022328e-03 0 5.501376872e-03 0 5.501386872e-03 1 5.526350386e-03 1 5.526360386e-03 0 5.526715089e-03 0 5.526725089e-03 1 5.551688331e-03 1
+ 5.551698331e-03 0 5.552053350e-03 0 5.552063350e-03 1 5.577026379e-03 1 5.577036379e-03 0 5.577391453e-03 0 5.577401453e-03 1 5.602364569e-03 1
+ 5.602374569e-03 0 5.602729435e-03 0 5.602739435e-03 1 5.627702860e-03 1 5.627712860e-03 0 5.628067394e-03 0 5.628077394e-03 1 5.653040983e-03 1
+ 5.653050983e-03 0 5.653405566e-03 0 5.653415566e-03 1 5.678378997e-03 1 5.678388997e-03 0 5.678743805e-03 0 5.678753805e-03 1 5.703716903e-03 1
+ 5.703726903e-03 0 5.704082070e-03 0 5.704092070e-03 1 5.729055074e-03 1 5.729065074e-03 0 5.729420041e-03 0 5.729430041e-03 1 5.754393265e-03 1
+ 5.754403265e-03 0 5.754758052e-03 0 5.754768052e-03 1 5.779731623e-03 1 5.779741623e-03 0 5.780095978e-03 0 5.780105978e-03 1 5.805069549e-03 1
+ 5.805079549e-03 0 5.805434348e-03 0 5.805444348e-03 1 5.830407655e-03 1 5.830417655e-03 0 5.830772457e-03 0 5.830782457e-03 1 5.855745408e-03 1
+ 5.855755408e-03 0 5.856110846e-03 0 5.856120846e-03 1 5.881083926e-03 1 5.881093926e-03 0 5.881448477e-03 0 5.881458477e-03 1 5.891668667e-03 1
+ 5.891678667e-03 0 8.733335333e-03 0 8.733835333e-03 1 8.758330096e-03 1 8.758340096e-03 0 8.758725142e-03 0 8.758735142e-03 1 8.783669210e-03 1
+ 8.783679210e-03 0 8.784034177e-03 0 8.784044177e-03 1 8.809007462e-03 1 8.809017462e-03 0 8.809372139e-03 0 8.809382139e-03 1 8.834345666e-03 1
+ 8.834355666e-03 0 8.834710212e-03 0 8.834720212e-03 1 8.859683725e-03 1 8.859693725e-03 0 8.860048428e-03 0 8.860058428e-03 1 8.885021673e-03 1
+ 8.885031673e-03 0 8.885386688e-03 0 8.885396688e-03 1 8.910359720e-03 1 8.910369720e-03 0 8.910724792e-03 0 8.910734792e-03 1 8.935697908e-03 1
+ 8.935707908e-03 0 8.936062776e-03 0 8.936072776e-03 1 8.961036197e-03 1 8.961046197e-03 0 8.961400736e-03 0 8.961410736e-03 1 8.986374322e-03 1
+ 8.986384322e-03 0 8.986738905e-03 0 8.986748905e-03 1 9.011712337e-03 1 9.011722337e-03 0 9.012077144e-03 0 9.012087144e-03 1 9.037050246e-03 1
+ 9.037060246e-03 0 9.037415407e-03 0 9.037425407e-03 1 9.062388413e-03 1 9.062398413e-03 0 9.062753382e-03 0 9.062763382e-03 1 9.087726605e-03 1
+ 9.087736605e-03 0 9.088091392e-03 0 9.088101392e-03 1 9.113064958e-03 1 9.113074958e-03 0 9.113429321e-03 0 9.113439321e-03 1 9.138402891e-03 1
+ 9.138412891e-03 0 9.138767684e-03 0 9.138777684e-03 1 9.163740994e-03 1 9.163750994e-03 0 9.164105798e-03 0 9.164115798e-03 1 9.189078754e-03 1
+ 9.189088754e-03 0 9.189444180e-03 0 9.189454180e-03 1 9.214417259e-03 1 9.214427259e-03 0 9.214781824e-03 0 9.214791824e-03 1 9.225002000e-03 1
+ 9.225012000e-03 0 1.206666867e-02 0 1.206716867e-02 1 1.209166343e-02 1 1.209167343e-02 0 1.209205848e-02 0 1.209206848e-02 1 1.211700255e-02 1
+ 1.211701255e-02 0 1.211736751e-02 0 1.211737751e-02 1 1.214234080e-02 1 1.214235080e-02 0 1.214270548e-02 0 1.214271548e-02 1 1.216767900e-02 1
+ 1.216768900e-02 0 1.216804355e-02 0 1.216805355e-02 1 1.219301706e-02 1 1.219302706e-02 0 1.219338176e-02 0 1.219339176e-02 1 1.221835501e-02 1
+ 1.221836501e-02 0 1.221872002e-02 0 1.221873002e-02 1 1.224369306e-02 1 1.224370306e-02 0 1.224405813e-02 0 1.224406813e-02 1 1.226903125e-02 1
+ 1.226904125e-02 0 1.226939611e-02 0 1.226940611e-02 1 1.229436953e-02 1 1.229437953e-02 0 1.229473407e-02 0 1.229474407e-02 1 1.231970766e-02 1
+ 1.231971766e-02 0 1.232007224e-02 0 1.232008224e-02 1 1.234504567e-02 1 1.234505567e-02 0 1.234541048e-02 0 1.234542048e-02 1 1.237038358e-02 1
+ 1.237039358e-02 0 1.237074874e-02 0 1.237075874e-02 1 1.239572175e-02 1 1.239573175e-02 0 1.239608672e-02 0 1.239609672e-02 1 1.242105994e-02 1
+ 1.242106994e-02 0 1.242142473e-02 0 1.242143473e-02 1 1.244639829e-02 1 1.244640829e-02 0 1.244676266e-02 0 1.244677266e-02 1 1.247173623e-02 1
+ 1.247174623e-02 0 1.247210102e-02 0 1.247211102e-02 1 1.249707433e-02 1 1.249708433e-02 0 1.249743913e-02 0 1.249744913e-02 1 1.252241209e-02 1
+ 1.252242209e-02 0 1.252277752e-02 0 1.252278752e-02 1 1.254775059e-02 1 1.254776059e-02 0 1.254811516e-02 0 1.254812516e-02 1 1.255833533e-02 1
+ 1.255834533e-02 0 1.540000200e-02 0 1.540050200e-02 1 1.542499675e-02 1 1.542500675e-02 0 1.542539179e-02 0 1.542540179e-02 1 1.545033586e-02 1
+ 1.545034586e-02 0 1.545070083e-02 0 1.545071083e-02 1 1.547567411e-02 1 1.547568411e-02 0 1.547603879e-02 0 1.547604879e-02 1 1.550101232e-02 1
+ 1.550102232e-02 0 1.550137686e-02 0 1.550138686e-02 1 1.552635038e-02 1 1.552636038e-02 0 1.552671508e-02 0 1.552672508e-02 1 1.555168832e-02 1
+ 1.555169832e-02 0 1.555205334e-02 0 1.555206334e-02 1 1.557702637e-02 1 1.557703637e-02 0 1.557739145e-02 0 1.557740145e-02 1 1.560236456e-02 1
+ 1.560237456e-02 0 1.560272943e-02 0 1.560273943e-02 1 1.562770285e-02 1 1.562771285e-02 0 1.562806738e-02 0 1.562807738e-02 1 1.565304098e-02 1
+ 1.565305098e-02 0 1.565340555e-02 0 1.565341555e-02 1 1.567837899e-02 1 1.567838899e-02 0 1.567874379e-02 0 1.567875379e-02 1 1.570371690e-02 1
+ 1.570372690e-02 0 1.570408206e-02 0 1.570409206e-02 1 1.572905506e-02 1 1.572906506e-02 0 1.572942004e-02 0 1.572943004e-02 1 1.575439325e-02 1
+ 1.575440325e-02 0 1.575475804e-02 0 1.575476804e-02 1 1.577973161e-02 1 1.577974161e-02 0 1.578009597e-02 0 1.578010597e-02 1 1.580506954e-02 1
+ 1.580507954e-02 0 1.580543433e-02 0 1.580544433e-02 1 1.583040764e-02 1 1.583041764e-02 0 1.583077245e-02 0 1.583078245e-02 1 1.585574540e-02 1
+ 1.585575540e-02 0 1.585611083e-02 0 1.585612083e-02 1 1.588108391e-02 1 1.588109391e-02 0 1.588144848e-02 0 1.588145848e-02 1 1.589166867e-02 1
+ 1.589167867e-02 0 1.873333533e-02 0 1.873383533e-02 1 1.875833008e-02 1 1.875834008e-02 0 1.875872513e-02 0 1.875873513e-02 1 1.878366919e-02 1
+ 1.878367919e-02 0 1.878403416e-02 0 1.878404416e-02 1 1.880900745e-02 1 1.880901745e-02 0 1.880937212e-02 0 1.880938212e-02 1 1.883434565e-02 1
+ 1.883435565e-02 0 1.883471020e-02 0 1.883472020e-02 1 1.885968371e-02 1 1.885969371e-02 0 1.886004841e-02 0 1.886005841e-02 1 1.888502166e-02 1
+ 1.888503166e-02 0 1.888538667e-02 0 1.888539667e-02 1 1.891035970e-02 1 1.891036970e-02 0 1.891072478e-02 0 1.891073478e-02 1 1.893569789e-02 1
+ 1.893570789e-02 0 1.893606276e-02 0 1.893607276e-02 1 1.896103618e-02 1 1.896104618e-02 0 1.896140072e-02 0 1.896141072e-02 1 1.898637431e-02 1
+ 1.898638431e-02 0 1.898673889e-02 0 1.898674889e-02 1 1.901171232e-02 1 1.901172232e-02 0 1.901207713e-02 0 1.901208713e-02 1 1.903705023e-02 1
+ 1.903706023e-02 0 1.903741539e-02 0 1.903742539e-02 1 1.906238840e-02 1 1.906239840e-02 0 1.906275337e-02 0 1.906276337e-02 1 1.908772659e-02 1
+ 1.908773659e-02 0 1.908809138e-02 0 1.908810138e-02 1 1.911306494e-02 1 1.911307494e-02 0 1.911342930e-02 0 1.911343930e-02 1 1.913840288e-02 1
+ 1.913841288e-02 0 1.913876767e-02 0 1.913877767e-02 1 1.916374098e-02 1 1.916375098e-02 0 1.916410578e-02 0 1.916411578e-02 1 1.918907874e-02 1
+ 1.918908874e-02 0 1.918944417e-02 0 1.918945417e-02 1 1.921441724e-02 1 1.921442724e-02 0 1.921478181e-02 0 1.921479181e-02 1 1.922500200e-02 1
+ 1.922501200e-02 0 2.206666867e-02 0 2.206716867e-02 1 2.209166340e-02 1 2.209167340e-02 0 2.209205845e-02 0 2.209206845e-02 1 2.211700252e-02 1
+ 2.211701252e-02 0 2.211736749e-02 0 2.211737749e-02 1 2.214234077e-02 1 2.214235077e-02 0 2.214270545e-02 0 2.214271545e-02 1 2.216767898e-02 1
+ 2.216768898e-02 0 2.216804352e-02 0 2.216805352e-02 1 2.219301704e-02 1 2.219302704e-02 0 2.219338174e-02 0 2.219339174e-02 1 2.221835498e-02 1
+ 2.221836498e-02 0 2.221872000e-02 0 2.221873000e-02 1 2.224369303e-02 1 2.224370303e-02 0 2.224405811e-02 0 2.224406811e-02 1 2.226903122e-02 1
+ 2.226904122e-02 0 2.226939609e-02 0 2.226940609e-02 1 2.229436951e-02 1 2.229437951e-02 0 2.229473404e-02 0 2.229474404e-02 1 2.231970764e-02 1
+ 2.231971764e-02 0 2.232007221e-02 0 2.232008221e-02 1 2.234504565e-02 1 2.234505565e-02 0 2.234541045e-02 0 2.234542045e-02 1 2.237038355e-02 1
+ 2.237039355e-02 0 2.237074872e-02 0 2.237075872e-02 1 2.239572172e-02 1 2.239573172e-02 0 2.239608670e-02 0 2.239609670e-02 1 2.242105991e-02 1
+ 2.242106991e-02 0 2.242142470e-02 0 2.242143470e-02 1 2.244639827e-02 1 2.244640827e-02 0 2.244676263e-02 0 2.244677263e-02 1 2.247173621e-02 1
+ 2.247174621e-02 0 2.247210099e-02 0 2.247211099e-02 1 2.249707430e-02 1 2.249708430e-02 0 2.249743911e-02 0 2.249744911e-02 1 2.252241206e-02 1
+ 2.252242206e-02 0 2.252277749e-02 0 2.252278749e-02 1 2.254775056e-02 1 2.254776056e-02 0 2.254811514e-02 0 2.254812514e-02 1 2.255833533e-02 1
+ 2.255834533e-02 0 2.540000200e-02 0 2.540050200e-02 1 2.542499674e-02 1 2.542500674e-02 0 2.542539179e-02 0 2.542540179e-02 1 2.545033586e-02 1
+ 2.545034586e-02 0 2.545070083e-02 0 2.545071083e-02 1 2.547567411e-02 1 2.547568411e-02 0 2.547603879e-02 0 2.547604879e-02 1 2.550101232e-02 1
+ 2.550102232e-02 0 2.550137686e-02 0 2.550138686e-02 1 2.552635038e-02 1 2.552636038e-02 0 2.552671507e-02 0 2.552672507e-02 1 2.555168832e-02 1
+ 2.555169832e-02 0 2.555205334e-02 0 2.555206334e-02 1 2.557702637e-02 1 2.557703637e-02 0 2.557739144e-02 0 2.557740144e-02 1 2.560236455e-02 1
+ 2.560237455e-02 0 2.560272943e-02 0 2.560273943e-02 1 2.562770285e-02 1 2.562771285e-02 0 2.562806738e-02 0 2.562807738e-02 1 2.565304097e-02 1
+ 2.565305097e-02 0 2.565340555e-02 0 2.565341555e-02 1 2.567837899e-02 1 2.567838899e-02 0 2.567874379e-02 0 2.567875379e-02 1 2.570371689e-02 1
+ 2.570372689e-02 0 2.570408206e-02 0 2.570409206e-02 1 2.572905506e-02 1 2.572906506e-02 0 2.572942003e-02 0 2.572943003e-02 1 2.575439325e-02 1
+ 2.575440325e-02 0 2.575475804e-02 0 2.575476804e-02 1 2.577973161e-02 1 2.577974161e-02 0 2.578009597e-02 0 2.578010597e-02 1 2.580506954e-02 1
+ 2.580507954e-02 0 2.580543433e-02 0 2.580544433e-02 1 2.583040764e-02 1 2.583041764e-02 0 2.583077245e-02 0 2.583078245e-02 1 2.585574540e-02 1
+ 2.585575540e-02 0 2.585611083e-02 0 2.585612083e-02 1 2.588108390e-02 1 2.588109390e-02 0 2.588144848e-02 0 2.588145848e-02 1 2.589166867e-02 1
+ 2.589167867e-02 0 2.873333533e-02 0 2.873383533e-02 1 2.875833008e-02 1 2.875834008e-02 0 2.875872513e-02 0 2.875873513e-02 1 2.878366919e-02 1
+ 2.878367919e-02 0 2.878403416e-02 0 2.878404416e-02 1 2.880900744e-02 1 2.880901744e-02 0 2.880937212e-02 0 2.880938212e-02 1 2.883434565e-02 1
+ 2.883435565e-02 0 2.883471019e-02 0 2.883472019e-02 1 2.885968371e-02 1 2.885969371e-02 0 2.886004841e-02 0 2.886005841e-02 1 2.888502166e-02 1
+ 2.888503166e-02 0 2.888538667e-02 0 2.888539667e-02 1 2.891035970e-02 1 2.891036970e-02 0 2.891072478e-02 0 2.891073478e-02 1 2.893569789e-02 1
+ 2.893570789e-02 0 2.893606276e-02 0 2.893607276e-02 1 2.896103618e-02 1 2.896104618e-02 0 2.896140072e-02 0 2.896141072e-02 1 2.898637431e-02 1
+ 2.898638431e-02 0 2.898673889e-02 0 2.898674889e-02 1 2.901171232e-02 1 2.901172232e-02 0 2.901207713e-02 0 2.901208713e-02 1 2.903705023e-02 1
+ 2.903706023e-02 0 2.903741539e-02 0 2.903742539e-02 1 2.906238839e-02 1 2.906239839e-02 0 2.906275337e-02 0 2.906276337e-02 1 2.908772659e-02 1
+ 2.908773659e-02 0 2.908809138e-02 0 2.908810138e-02 1 2.911306494e-02 1 2.911307494e-02 0 2.911342930e-02 0 2.911343930e-02 1 2.913840288e-02 1
+ 2.913841288e-02 0 2.913876766e-02 0 2.913877766e-02 1 2.916374098e-02 1 2.916375098e-02 0 2.916410578e-02 0 2.916411578e-02 1 2.918907874e-02 1
+ 2.918908874e-02 0 2.918944417e-02 0 2.918945417e-02 1 2.921441724e-02 1 2.921442724e-02 0 2.921478181e-02 0 2.921479181e-02 1 2.922500200e-02 1
+ 2.922501200e-02 0 3.206666867e-02 0 3.206716867e-02 1 3.209166341e-02 1 3.209167341e-02 0 3.209205846e-02 0 3.209206846e-02 1 3.211700252e-02 1
+ 3.211701252e-02 0 3.211736749e-02 0 3.211737749e-02 1 3.214234078e-02 1 3.214235078e-02 0 3.214270545e-02 0 3.214271545e-02 1 3.216767898e-02 1
+ 3.216768898e-02 0 3.216804353e-02 0 3.216805353e-02 1 3.219301704e-02 1 3.219302704e-02 0 3.219338174e-02 0 3.219339174e-02 1 3.221835499e-02 1
+ 3.221836499e-02 0 3.221872000e-02 0 3.221873000e-02 1 3.224369303e-02 1 3.224370303e-02 0 3.224405811e-02 0 3.224406811e-02 1 3.226903122e-02 1
+ 3.226904122e-02 0 3.226939609e-02 0 3.226940609e-02 1 3.229436951e-02 1 3.229437951e-02 0 3.229473405e-02 0 3.229474405e-02 1 3.231970764e-02 1
+ 3.231971764e-02 0 3.232007222e-02 0 3.232008222e-02 1 3.234504565e-02 1 3.234505565e-02 0 3.234541046e-02 0 3.234542046e-02 1 3.237038356e-02 1
+ 3.237039356e-02 0 3.237074872e-02 0 3.237075872e-02 1 3.239572173e-02 1 3.239573173e-02 0 3.239608670e-02 0 3.239609670e-02 1 3.242105992e-02 1
+ 3.242106992e-02 0 3.242142471e-02 0 3.242143471e-02 1 3.244639828e-02 1 3.244640828e-02 0 3.244676263e-02 0 3.244677263e-02 1 3.247173621e-02 1
+ 3.247174621e-02 0 3.247210100e-02 0 3.247211100e-02 1 3.249707431e-02 1 3.249708431e-02 0 3.249743911e-02 0 3.249744911e-02 1 3.252241207e-02 1
+ 3.252242207e-02 0 3.252277750e-02 0 3.252278750e-02 1 3.254775057e-02 1 3.254776057e-02 0 3.254811514e-02 0 3.254812514e-02 1 3.255833533e-02 1
+ 3.255834533e-02 0 3.540000200e-02 0 3.540050200e-02 1 3.542499674e-02 1 3.542500674e-02 0 3.542539179e-02 0 3.542540179e-02 1 3.545033586e-02 1
+ 3.545034586e-02 0 3.545070083e-02 0 3.545071083e-02 1 3.547567411e-02 1 3.547568411e-02 0 3.547603879e-02 0 3.547604879e-02 1 3.550101232e-02 1
+ 3.550102232e-02 0 3.550137686e-02 0 3.550138686e-02 1 3.552635038e-02 1 3.552636038e-02 0 3.552671508e-02 0 3.552672508e-02 1 3.555168832e-02 1
+ 3.555169832e-02 0 3.555205334e-02 0 3.555206334e-02 1 3.557702637e-02 1 3.557703637e-02 0 3.557739144e-02 0 3.557740144e-02 1 3.560236456e-02 1
+ 3.560237456e-02 0 3.560272943e-02 0 3.560273943e-02 1 3.562770285e-02 1 3.562771285e-02 0 3.562806738e-02 0 3.562807738e-02 1 3.565304097e-02 1
+ 3.565305097e-02 0 3.565340555e-02 0 3.565341555e-02 1 3.567837899e-02 1 3.567838899e-02 0 3.567874379e-02 0 3.567875379e-02 1 3.570371689e-02 1
+ 3.570372689e-02 0 3.570408206e-02 0 3.570409206e-02 1 3.572905506e-02 1 3.572906506e-02 0 3.572942003e-02 0 3.572943003e-02 1 3.575439325e-02 1
+ 3.575440325e-02 0 3.575475804e-02 0 3.575476804e-02 1 3.577973161e-02 1 3.577974161e-02 0 3.578009597e-02 0 3.578010597e-02 1 3.580506954e-02 1
+ 3.580507954e-02 0 3.580543433e-02 0 3.580544433e-02 1 3.583040764e-02 1 3.583041764e-02 0 3.583077245e-02 0 3.583078245e-02 1 3.585574540e-02 1
+ 3.585575540e-02 0 3.585611083e-02 0 3.585612083e-02 1 3.588108390e-02 1 3.588109390e-02 0 3.588144848e-02 0 3.588145848e-02 1 3.589166867e-02 1
+ 3.589167867e-02 0 3.873333533e-02 0 3.873383533e-02 1 3.875833008e-02 1 3.875834008e-02 0 3.875872513e-02 0 3.875873513e-02 1 3.878366920e-02 1
+ 3.878367920e-02 0 3.878403417e-02 0 3.878404417e-02 1 3.880900745e-02 1 3.880901745e-02 0 3.880937213e-02 0 3.880938213e-02 1 3.883434566e-02 1
+ 3.883435566e-02 0 3.883471020e-02 0 3.883472020e-02 1 3.885968372e-02 1 3.885969372e-02 0 3.886004842e-02 0 3.886005842e-02 1 3.888502166e-02 1
+ 3.888503166e-02 0 3.888538668e-02 0 3.888539668e-02 1 3.891035971e-02 1 3.891036971e-02 0 3.891072478e-02 0 3.891073478e-02 1 3.893569790e-02 1
+ 3.893570790e-02 0 3.893606277e-02 0 3.893607277e-02 1 3.896103619e-02 1 3.896104619e-02 0 3.896140072e-02 0 3.896141072e-02 1 3.898637431e-02 1
+ 3.898638431e-02 0 3.898673889e-02 0 3.898674889e-02 1 3.901171233e-02 1 3.901172233e-02 0 3.901207713e-02 0 3.901208713e-02 1 3.903705023e-02 1
+ 3.903706023e-02 0 3.903741540e-02 0 3.903742540e-02 1 3.906238840e-02 1 3.906239840e-02 0 3.906275337e-02 0 3.906276337e-02 1 3.908772659e-02 1
+ 3.908773659e-02 0 3.908809138e-02 0 3.908810138e-02 1 3.911306495e-02 1 3.911307495e-02 0 3.911342931e-02 0 3.911343931e-02 1 3.913840288e-02 1
+ 3.913841288e-02 0 3.913876767e-02 0 3.913877767e-02 1 3.916374098e-02 1 3.916375098e-02 0 3.916410579e-02 0 3.916411579e-02 1 3.918907874e-02 1
+ 3.918908874e-02 0 3.918944417e-02 0 3.918945417e-02 1 3.921441724e-02 1 3.921442724e-02 0 3.921478181e-02 0 3.921479181e-02 1 3.922500200e-02 1
+ 3.922501200e-02 0 4.206666867e-02 0 4.206716867e-02 1 4.209166342e-02 1 4.209167342e-02 0 4.209205846e-02 0 4.209206846e-02 1 4.211700253e-02 1
+ 4.211701253e-02 0 4.211736750e-02 0 4.211737750e-02 1 4.214234078e-02 1 4.214235078e-02 0 4.214270546e-02 0 4.214271546e-02 1 4.216767899e-02 1
+ 4.216768899e-02 0 4.216804353e-02 0 4.216805353e-02 1 4.219301705e-02 1 4.219302705e-02 0 4.219338175e-02 0 4.219339175e-02 1 4.221835499e-02 1
+ 4.221836499e-02 0 4.221872001e-02 0 4.221873001e-02 1 4.224369304e-02 1 4.224370304e-02 0 4.224405811e-02 0 4.224406811e-02 1 4.226903123e-02 1
+ 4.226904123e-02 0 4.226939610e-02 0 4.226940610e-02 1 4.229436952e-02 1 4.229437952e-02 0 4.229473406e-02 0 4.229474406e-02 1 4.231970764e-02 1
+ 4.231971764e-02 0 4.232007222e-02 0 4.232008222e-02 1 4.234504566e-02 1 4.234505566e-02 0 4.234541046e-02 0 4.234542046e-02 1 4.237038357e-02 1
+ 4.237039357e-02 0 4.237074873e-02 0 4.237075873e-02 1 4.239572173e-02 1 4.239573173e-02 0 4.239608670e-02 0 4.239609670e-02 1 4.242105992e-02 1
+ 4.242106992e-02 0 4.242142471e-02 0 4.242143471e-02 1 4.244639828e-02 1 4.244640828e-02 0 4.244676264e-02 0 4.244677264e-02 1 4.247173621e-02 1
+ 4.247174621e-02 0 4.247210100e-02 0 4.247211100e-02 1 4.249707431e-02 1 4.249708431e-02 0 4.249743912e-02 0 4.249744912e-02 1 4.252241207e-02 1
+ 4.252242207e-02 0 4.252277750e-02 0 4.252278750e-02 1 4.254775058e-02 1 4.254776058e-02 0 4.254811515e-02 0 4.254812515e-02 1 4.255833533e-02 1
+ 4.255834533e-02 0 4.433333333e-02 0)
V_mf_sg4a1 mf_sg4a1 0 PWL(0.000000000e+00 0 2.091663425e-03 0 2.091673425e-03 1 2.092008501e-03 1 2.092018501e-03 0 2.142340817e-03 0 2.142350817e-03 1 2.142685459e-03 1
+ 2.142695459e-03 0 2.193017054e-03 0 2.193027054e-03 1 2.193361779e-03 1 2.193371779e-03 0 2.243693054e-03 0 2.243703054e-03 1 2.244038124e-03 1
+ 2.244048124e-03 0 2.294369556e-03 0 2.294379556e-03 1 2.294714056e-03 1 2.294724056e-03 0 2.345045664e-03 0 2.345055664e-03 1 2.345390493e-03 1
+ 2.345400493e-03 0 2.395721767e-03 0 2.395731767e-03 1 2.396066693e-03 1 2.396076693e-03 0 2.446398332e-03 0 2.446408332e-03 1 2.446742630e-03 1
+ 2.446752630e-03 0 2.497074349e-03 0 2.497084349e-03 1 2.497419114e-03 1 2.497429114e-03 0 2.547750680e-03 0 2.547760680e-03 1 2.548095070e-03 1
+ 2.548105070e-03 0 5.424996755e-03 0 5.425006755e-03 1 5.425341818e-03 1 5.425351818e-03 0 5.475674124e-03 0 5.475684124e-03 1 5.476018798e-03 1
+ 5.476028798e-03 0 5.526350386e-03 0 5.526360386e-03 1 5.526695089e-03 1 5.526705089e-03 0 5.577026379e-03 0 5.577036379e-03 1 5.577371453e-03 1
+ 5.577381453e-03 0 5.627702860e-03 0 5.627712860e-03 1 5.628047394e-03 1 5.628057394e-03 0 5.678378997e-03 0 5.678388997e-03 1 5.678723805e-03 1
+ 5.678733805e-03 0 5.729055074e-03 0 5.729065074e-03 1 5.729400041e-03 1 5.729410041e-03 0 5.779731623e-03 0 5.779741623e-03 1 5.780075978e-03 1
+ 5.780085978e-03 0 5.830407655e-03 0 5.830417655e-03 1 5.830752457e-03 1 5.830762457e-03 0 5.881083926e-03 0 5.881093926e-03 1 5.881428477e-03 1
+ 5.881438477e-03 0 8.758330096e-03 0 8.758340096e-03 1 8.758675156e-03 1 8.758685156e-03 0 8.809007462e-03 0 8.809017462e-03 1 8.809352139e-03 1
+ 8.809362139e-03 0 8.859683725e-03 0 8.859693725e-03 1 8.860028428e-03 1 8.860038428e-03 0 8.910359720e-03 0 8.910369720e-03 1 8.910704792e-03 1
+ 8.910714792e-03 0 8.961036197e-03 0 8.961046197e-03 1 8.961380736e-03 1 8.961390736e-03 0 9.011712337e-03 0 9.011722337e-03 1 9.012057144e-03 1
+ 9.012067144e-03 0 9.062388413e-03 0 9.062398413e-03 1 9.062733382e-03 1 9.062743382e-03 0 9.113064958e-03 0 9.113074958e-03 1 9.113409321e-03 1
+ 9.113419321e-03 0 9.163740994e-03 0 9.163750994e-03 1 9.164085798e-03 1 9.164095798e-03 0 9.214417259e-03 0 9.214427259e-03 1 9.214761824e-03 1
+ 9.214771824e-03 0 1.209166343e-02 0 1.209167343e-02 1 1.209200849e-02 1 1.209201849e-02 0 1.214234080e-02 0 1.214235080e-02 1 1.214268548e-02 1
+ 1.214269548e-02 0 1.219301706e-02 0 1.219302706e-02 1 1.219336176e-02 1 1.219337176e-02 0 1.224369306e-02 0 1.224370306e-02 1 1.224403813e-02 1
+ 1.224404813e-02 0 1.229436953e-02 0 1.229437953e-02 1 1.229471407e-02 1 1.229472407e-02 0 1.234504567e-02 0 1.234505567e-02 1 1.234539048e-02 1
+ 1.234540048e-02 0 1.239572175e-02 0 1.239573175e-02 1 1.239606672e-02 1 1.239607672e-02 0 1.244639829e-02 0 1.244640829e-02 1 1.244674266e-02 1
+ 1.244675266e-02 0 1.249707433e-02 0 1.249708433e-02 1 1.249741913e-02 1 1.249742913e-02 0 1.254775059e-02 0 1.254776059e-02 1 1.254809516e-02 1
+ 1.254810516e-02 0 1.542499675e-02 0 1.542500675e-02 1 1.542534181e-02 1 1.542535181e-02 0 1.547567411e-02 0 1.547568411e-02 1 1.547601879e-02 1
+ 1.547602879e-02 0 1.552635038e-02 0 1.552636038e-02 1 1.552669508e-02 1 1.552670508e-02 0 1.557702637e-02 0 1.557703637e-02 1 1.557737145e-02 1
+ 1.557738145e-02 0 1.562770285e-02 0 1.562771285e-02 1 1.562804738e-02 1 1.562805738e-02 0 1.567837899e-02 0 1.567838899e-02 1 1.567872379e-02 1
+ 1.567873379e-02 0 1.572905506e-02 0 1.572906506e-02 1 1.572940004e-02 1 1.572941004e-02 0 1.577973161e-02 0 1.577974161e-02 1 1.578007597e-02 1
+ 1.578008597e-02 0 1.583040764e-02 0 1.583041764e-02 1 1.583075245e-02 1 1.583076245e-02 0 1.588108391e-02 0 1.588109391e-02 1 1.588142848e-02 1
+ 1.588143848e-02 0 1.875833008e-02 0 1.875834008e-02 1 1.875867514e-02 1 1.875868514e-02 0 1.880900745e-02 0 1.880901745e-02 1 1.880935212e-02 1
+ 1.880936212e-02 0 1.885968371e-02 0 1.885969371e-02 1 1.886002841e-02 1 1.886003841e-02 0 1.891035970e-02 0 1.891036970e-02 1 1.891070478e-02 1
+ 1.891071478e-02 0 1.896103618e-02 0 1.896104618e-02 1 1.896138072e-02 1 1.896139072e-02 0 1.901171232e-02 0 1.901172232e-02 1 1.901205713e-02 1
+ 1.901206713e-02 0 1.906238840e-02 0 1.906239840e-02 1 1.906273337e-02 1 1.906274337e-02 0 1.911306494e-02 0 1.911307494e-02 1 1.911340930e-02 1
+ 1.911341930e-02 0 1.916374098e-02 0 1.916375098e-02 1 1.916408578e-02 1 1.916409578e-02 0 1.921441724e-02 0 1.921442724e-02 1 1.921476181e-02 1
+ 1.921477181e-02 0 2.209166340e-02 0 2.209167340e-02 1 2.209200847e-02 1 2.209201847e-02 0 2.214234077e-02 0 2.214235077e-02 1 2.214268545e-02 1
+ 2.214269545e-02 0 2.219301704e-02 0 2.219302704e-02 1 2.219336174e-02 1 2.219337174e-02 0 2.224369303e-02 0 2.224370303e-02 1 2.224403811e-02 1
+ 2.224404811e-02 0 2.229436951e-02 0 2.229437951e-02 1 2.229471404e-02 1 2.229472404e-02 0 2.234504565e-02 0 2.234505565e-02 1 2.234539045e-02 1
+ 2.234540045e-02 0 2.239572172e-02 0 2.239573172e-02 1 2.239606670e-02 1 2.239607670e-02 0 2.244639827e-02 0 2.244640827e-02 1 2.244674263e-02 1
+ 2.244675263e-02 0 2.249707430e-02 0 2.249708430e-02 1 2.249741911e-02 1 2.249742911e-02 0 2.254775056e-02 0 2.254776056e-02 1 2.254809514e-02 1
+ 2.254810514e-02 0 2.542499674e-02 0 2.542500674e-02 1 2.542534181e-02 1 2.542535181e-02 0 2.547567411e-02 0 2.547568411e-02 1 2.547601879e-02 1
+ 2.547602879e-02 0 2.552635038e-02 0 2.552636038e-02 1 2.552669507e-02 1 2.552670507e-02 0 2.557702637e-02 0 2.557703637e-02 1 2.557737144e-02 1
+ 2.557738144e-02 0 2.562770285e-02 0 2.562771285e-02 1 2.562804738e-02 1 2.562805738e-02 0 2.567837899e-02 0 2.567838899e-02 1 2.567872379e-02 1
+ 2.567873379e-02 0 2.572905506e-02 0 2.572906506e-02 1 2.572940003e-02 1 2.572941003e-02 0 2.577973161e-02 0 2.577974161e-02 1 2.578007597e-02 1
+ 2.578008597e-02 0 2.583040764e-02 0 2.583041764e-02 1 2.583075245e-02 1 2.583076245e-02 0 2.588108390e-02 0 2.588109390e-02 1 2.588142848e-02 1
+ 2.588143848e-02 0 2.875833008e-02 0 2.875834008e-02 1 2.875867514e-02 1 2.875868514e-02 0 2.880900744e-02 0 2.880901744e-02 1 2.880935212e-02 1
+ 2.880936212e-02 0 2.885968371e-02 0 2.885969371e-02 1 2.886002841e-02 1 2.886003841e-02 0 2.891035970e-02 0 2.891036970e-02 1 2.891070478e-02 1
+ 2.891071478e-02 0 2.896103618e-02 0 2.896104618e-02 1 2.896138072e-02 1 2.896139072e-02 0 2.901171232e-02 0 2.901172232e-02 1 2.901205713e-02 1
+ 2.901206713e-02 0 2.906238839e-02 0 2.906239839e-02 1 2.906273337e-02 1 2.906274337e-02 0 2.911306494e-02 0 2.911307494e-02 1 2.911340930e-02 1
+ 2.911341930e-02 0 2.916374098e-02 0 2.916375098e-02 1 2.916408578e-02 1 2.916409578e-02 0 2.921441724e-02 0 2.921442724e-02 1 2.921476181e-02 1
+ 2.921477181e-02 0 3.209166341e-02 0 3.209167341e-02 1 3.209200847e-02 1 3.209201847e-02 0 3.214234078e-02 0 3.214235078e-02 1 3.214268545e-02 1
+ 3.214269545e-02 0 3.219301704e-02 0 3.219302704e-02 1 3.219336174e-02 1 3.219337174e-02 0 3.224369303e-02 0 3.224370303e-02 1 3.224403811e-02 1
+ 3.224404811e-02 0 3.229436951e-02 0 3.229437951e-02 1 3.229471405e-02 1 3.229472405e-02 0 3.234504565e-02 0 3.234505565e-02 1 3.234539046e-02 1
+ 3.234540046e-02 0 3.239572173e-02 0 3.239573173e-02 1 3.239606670e-02 1 3.239607670e-02 0 3.244639828e-02 0 3.244640828e-02 1 3.244674263e-02 1
+ 3.244675263e-02 0 3.249707431e-02 0 3.249708431e-02 1 3.249741911e-02 1 3.249742911e-02 0 3.254775057e-02 0 3.254776057e-02 1 3.254809514e-02 1
+ 3.254810514e-02 0 3.542499674e-02 0 3.542500674e-02 1 3.542534181e-02 1 3.542535181e-02 0 3.547567411e-02 0 3.547568411e-02 1 3.547601879e-02 1
+ 3.547602879e-02 0 3.552635038e-02 0 3.552636038e-02 1 3.552669508e-02 1 3.552670508e-02 0 3.557702637e-02 0 3.557703637e-02 1 3.557737144e-02 1
+ 3.557738144e-02 0 3.562770285e-02 0 3.562771285e-02 1 3.562804738e-02 1 3.562805738e-02 0 3.567837899e-02 0 3.567838899e-02 1 3.567872379e-02 1
+ 3.567873379e-02 0 3.572905506e-02 0 3.572906506e-02 1 3.572940003e-02 1 3.572941003e-02 0 3.577973161e-02 0 3.577974161e-02 1 3.578007597e-02 1
+ 3.578008597e-02 0 3.583040764e-02 0 3.583041764e-02 1 3.583075245e-02 1 3.583076245e-02 0 3.588108390e-02 0 3.588109390e-02 1 3.588142848e-02 1
+ 3.588143848e-02 0 3.875833008e-02 0 3.875834008e-02 1 3.875867515e-02 1 3.875868515e-02 0 3.880900745e-02 0 3.880901745e-02 1 3.880935213e-02 1
+ 3.880936213e-02 0 3.885968372e-02 0 3.885969372e-02 1 3.886002842e-02 1 3.886003842e-02 0 3.891035971e-02 0 3.891036971e-02 1 3.891070478e-02 1
+ 3.891071478e-02 0 3.896103619e-02 0 3.896104619e-02 1 3.896138072e-02 1 3.896139072e-02 0 3.901171233e-02 0 3.901172233e-02 1 3.901205713e-02 1
+ 3.901206713e-02 0 3.906238840e-02 0 3.906239840e-02 1 3.906273337e-02 1 3.906274337e-02 0 3.911306495e-02 0 3.911307495e-02 1 3.911340931e-02 1
+ 3.911341931e-02 0 3.916374098e-02 0 3.916375098e-02 1 3.916408579e-02 1 3.916409579e-02 0 3.921441724e-02 0 3.921442724e-02 1 3.921476181e-02 1
+ 3.921477181e-02 0 4.209166342e-02 0 4.209167342e-02 1 4.209200848e-02 1 4.209201848e-02 0 4.214234078e-02 0 4.214235078e-02 1 4.214268546e-02 1
+ 4.214269546e-02 0 4.219301705e-02 0 4.219302705e-02 1 4.219336175e-02 1 4.219337175e-02 0 4.224369304e-02 0 4.224370304e-02 1 4.224403811e-02 1
+ 4.224404811e-02 0 4.229436952e-02 0 4.229437952e-02 1 4.229471406e-02 1 4.229472406e-02 0 4.234504566e-02 0 4.234505566e-02 1 4.234539046e-02 1
+ 4.234540046e-02 0 4.239572173e-02 0 4.239573173e-02 1 4.239606670e-02 1 4.239607670e-02 0 4.244639828e-02 0 4.244640828e-02 1 4.244674264e-02 1
+ 4.244675264e-02 0 4.249707431e-02 0 4.249708431e-02 1 4.249741912e-02 1 4.249742912e-02 0 4.254775058e-02 0 4.254776058e-02 1 4.254809515e-02 1
+ 4.254810515e-02 0 4.433333333e-02 0)
V_mr_sg4a1 mr_sg4a1 0 PWL(0.000000000e+00 0 2.117002552e-03 0 2.117012552e-03 1 2.117347502e-03 1 2.117357502e-03 0 2.167679011e-03 0 2.167689011e-03 1 2.168023549e-03 1
+ 2.168033549e-03 0 2.218354990e-03 0 2.218364990e-03 1 2.218700041e-03 1 2.218710041e-03 0 2.269031256e-03 0 2.269041256e-03 1 2.269376098e-03 1
+ 2.269386098e-03 0 2.319707654e-03 0 2.319717654e-03 1 2.320052256e-03 1 2.320062256e-03 0 2.370383556e-03 0 2.370393556e-03 1 2.370728764e-03 1
+ 2.370738764e-03 0 2.421059944e-03 0 2.421069944e-03 1 2.421404726e-03 1 2.421414726e-03 0 2.471736188e-03 0 2.471746188e-03 1 2.472081068e-03 1
+ 2.472091068e-03 0 2.522412028e-03 0 2.522422028e-03 1 2.522757570e-03 1 2.522767570e-03 0 2.558335333e-03 0 2.558345333e-03 1 2.558367955e-03 1
+ 2.558867955e-03 0 5.450335870e-03 0 5.450345870e-03 1 5.450680837e-03 1 5.450690837e-03 0 5.501012328e-03 0 5.501022328e-03 1 5.501356872e-03 1
+ 5.501366872e-03 0 5.551688331e-03 0 5.551698331e-03 1 5.552033350e-03 1 5.552043350e-03 0 5.602364569e-03 0 5.602374569e-03 1 5.602709435e-03 1
+ 5.602719435e-03 0 5.653040983e-03 0 5.653050983e-03 1 5.653385566e-03 1 5.653395566e-03 0 5.703716903e-03 0 5.703726903e-03 1 5.704062070e-03 1
+ 5.704072070e-03 0 5.754393265e-03 0 5.754403265e-03 1 5.754738052e-03 1 5.754748052e-03 0 5.805069549e-03 0 5.805079549e-03 1 5.805414348e-03 1
+ 5.805424348e-03 0 5.855745408e-03 0 5.855755408e-03 1 5.856090846e-03 1 5.856100846e-03 0 5.891668667e-03 0 5.891678667e-03 1 5.891701187e-03 1
+ 5.892201187e-03 0 8.783669210e-03 0 8.783679210e-03 1 8.784014177e-03 1 8.784024177e-03 0 8.834345666e-03 0 8.834355666e-03 1 8.834690212e-03 1
+ 8.834700212e-03 0 8.885021673e-03 0 8.885031673e-03 1 8.885366688e-03 1 8.885376688e-03 0 8.935697908e-03 0 8.935707908e-03 1 8.936042776e-03 1
+ 8.936052776e-03 0 8.986374322e-03 0 8.986384322e-03 1 8.986718905e-03 1 8.986728905e-03 0 9.037050246e-03 0 9.037060246e-03 1 9.037395407e-03 1
+ 9.037405407e-03 0 9.087726605e-03 0 9.087736605e-03 1 9.088071392e-03 1 9.088081392e-03 0 9.138402891e-03 0 9.138412891e-03 1 9.138747684e-03 1
+ 9.138757684e-03 0 9.189078754e-03 0 9.189088754e-03 1 9.189424180e-03 1 9.189434180e-03 0 9.225002000e-03 0 9.225012000e-03 1 9.225034517e-03 1
+ 9.225534517e-03 0 1.211700255e-02 0 1.211701255e-02 1 1.211734751e-02 1 1.211735751e-02 0 1.216767900e-02 0 1.216768900e-02 1 1.216802355e-02 1
+ 1.216803355e-02 0 1.221835501e-02 0 1.221836501e-02 1 1.221870002e-02 1 1.221871002e-02 0 1.226903125e-02 0 1.226904125e-02 1 1.226937611e-02 1
+ 1.226938611e-02 0 1.231970766e-02 0 1.231971766e-02 1 1.232005224e-02 1 1.232006224e-02 0 1.237038358e-02 0 1.237039358e-02 1 1.237072874e-02 1
+ 1.237073874e-02 0 1.242105994e-02 0 1.242106994e-02 1 1.242140473e-02 1 1.242141473e-02 0 1.247173623e-02 0 1.247174623e-02 1 1.247208102e-02 1
+ 1.247209102e-02 0 1.252241209e-02 0 1.252242209e-02 1 1.252275752e-02 1 1.252276752e-02 0 1.255833533e-02 0 1.255834533e-02 1 1.255836785e-02 1
+ 1.255886785e-02 0 1.545033586e-02 0 1.545034586e-02 1 1.545068083e-02 1 1.545069083e-02 0 1.550101232e-02 0 1.550102232e-02 1 1.550135686e-02 1
+ 1.550136686e-02 0 1.555168832e-02 0 1.555169832e-02 1 1.555203334e-02 1 1.555204334e-02 0 1.560236456e-02 0 1.560237456e-02 1 1.560270943e-02 1
+ 1.560271943e-02 0 1.565304098e-02 0 1.565305098e-02 1 1.565338555e-02 1 1.565339555e-02 0 1.570371690e-02 0 1.570372690e-02 1 1.570406206e-02 1
+ 1.570407206e-02 0 1.575439325e-02 0 1.575440325e-02 1 1.575473804e-02 1 1.575474804e-02 0 1.580506954e-02 0 1.580507954e-02 1 1.580541433e-02 1
+ 1.580542433e-02 0 1.585574540e-02 0 1.585575540e-02 1 1.585609083e-02 1 1.585610083e-02 0 1.589166867e-02 0 1.589167867e-02 1 1.589170117e-02 1
+ 1.589220117e-02 0 1.878366919e-02 0 1.878367919e-02 1 1.878401416e-02 1 1.878402416e-02 0 1.883434565e-02 0 1.883435565e-02 1 1.883469020e-02 1
+ 1.883470020e-02 0 1.888502166e-02 0 1.888503166e-02 1 1.888536667e-02 1 1.888537667e-02 0 1.893569789e-02 0 1.893570789e-02 1 1.893604276e-02 1
+ 1.893605276e-02 0 1.898637431e-02 0 1.898638431e-02 1 1.898671889e-02 1 1.898672889e-02 0 1.903705023e-02 0 1.903706023e-02 1 1.903739539e-02 1
+ 1.903740539e-02 0 1.908772659e-02 0 1.908773659e-02 1 1.908807138e-02 1 1.908808138e-02 0 1.913840288e-02 0 1.913841288e-02 1 1.913874767e-02 1
+ 1.913875767e-02 0 1.918907874e-02 0 1.918908874e-02 1 1.918942417e-02 1 1.918943417e-02 0 1.922500200e-02 0 1.922501200e-02 1 1.922503450e-02 1
+ 1.922553450e-02 0 2.211700252e-02 0 2.211701252e-02 1 2.211734749e-02 1 2.211735749e-02 0 2.216767898e-02 0 2.216768898e-02 1 2.216802352e-02 1
+ 2.216803352e-02 0 2.221835498e-02 0 2.221836498e-02 1 2.221870000e-02 1 2.221871000e-02 0 2.226903122e-02 0 2.226904122e-02 1 2.226937609e-02 1
+ 2.226938609e-02 0 2.231970764e-02 0 2.231971764e-02 1 2.232005221e-02 1 2.232006221e-02 0 2.237038355e-02 0 2.237039355e-02 1 2.237072872e-02 1
+ 2.237073872e-02 0 2.242105991e-02 0 2.242106991e-02 1 2.242140470e-02 1 2.242141470e-02 0 2.247173621e-02 0 2.247174621e-02 1 2.247208099e-02 1
+ 2.247209099e-02 0 2.252241206e-02 0 2.252242206e-02 1 2.252275749e-02 1 2.252276749e-02 0 2.255833533e-02 0 2.255834533e-02 1 2.255836783e-02 1
+ 2.255886783e-02 0 2.545033586e-02 0 2.545034586e-02 1 2.545068083e-02 1 2.545069083e-02 0 2.550101232e-02 0 2.550102232e-02 1 2.550135686e-02 1
+ 2.550136686e-02 0 2.555168832e-02 0 2.555169832e-02 1 2.555203334e-02 1 2.555204334e-02 0 2.560236455e-02 0 2.560237455e-02 1 2.560270943e-02 1
+ 2.560271943e-02 0 2.565304097e-02 0 2.565305097e-02 1 2.565338555e-02 1 2.565339555e-02 0 2.570371689e-02 0 2.570372689e-02 1 2.570406206e-02 1
+ 2.570407206e-02 0 2.575439325e-02 0 2.575440325e-02 1 2.575473804e-02 1 2.575474804e-02 0 2.580506954e-02 0 2.580507954e-02 1 2.580541433e-02 1
+ 2.580542433e-02 0 2.585574540e-02 0 2.585575540e-02 1 2.585609083e-02 1 2.585610083e-02 0 2.589166867e-02 0 2.589167867e-02 1 2.589170116e-02 1
+ 2.589220116e-02 0 2.878366919e-02 0 2.878367919e-02 1 2.878401416e-02 1 2.878402416e-02 0 2.883434565e-02 0 2.883435565e-02 1 2.883469019e-02 1
+ 2.883470019e-02 0 2.888502166e-02 0 2.888503166e-02 1 2.888536667e-02 1 2.888537667e-02 0 2.893569789e-02 0 2.893570789e-02 1 2.893604276e-02 1
+ 2.893605276e-02 0 2.898637431e-02 0 2.898638431e-02 1 2.898671889e-02 1 2.898672889e-02 0 2.903705023e-02 0 2.903706023e-02 1 2.903739539e-02 1
+ 2.903740539e-02 0 2.908772659e-02 0 2.908773659e-02 1 2.908807138e-02 1 2.908808138e-02 0 2.913840288e-02 0 2.913841288e-02 1 2.913874766e-02 1
+ 2.913875766e-02 0 2.918907874e-02 0 2.918908874e-02 1 2.918942417e-02 1 2.918943417e-02 0 2.922500200e-02 0 2.922501200e-02 1 2.922503450e-02 1
+ 2.922553450e-02 0 3.211700252e-02 0 3.211701252e-02 1 3.211734749e-02 1 3.211735749e-02 0 3.216767898e-02 0 3.216768898e-02 1 3.216802353e-02 1
+ 3.216803353e-02 0 3.221835499e-02 0 3.221836499e-02 1 3.221870000e-02 1 3.221871000e-02 0 3.226903122e-02 0 3.226904122e-02 1 3.226937609e-02 1
+ 3.226938609e-02 0 3.231970764e-02 0 3.231971764e-02 1 3.232005222e-02 1 3.232006222e-02 0 3.237038356e-02 0 3.237039356e-02 1 3.237072872e-02 1
+ 3.237073872e-02 0 3.242105992e-02 0 3.242106992e-02 1 3.242140471e-02 1 3.242141471e-02 0 3.247173621e-02 0 3.247174621e-02 1 3.247208100e-02 1
+ 3.247209100e-02 0 3.252241207e-02 0 3.252242207e-02 1 3.252275750e-02 1 3.252276750e-02 0 3.255833533e-02 0 3.255834533e-02 1 3.255836783e-02 1
+ 3.255886783e-02 0 3.545033586e-02 0 3.545034586e-02 1 3.545068083e-02 1 3.545069083e-02 0 3.550101232e-02 0 3.550102232e-02 1 3.550135686e-02 1
+ 3.550136686e-02 0 3.555168832e-02 0 3.555169832e-02 1 3.555203334e-02 1 3.555204334e-02 0 3.560236456e-02 0 3.560237456e-02 1 3.560270943e-02 1
+ 3.560271943e-02 0 3.565304097e-02 0 3.565305097e-02 1 3.565338555e-02 1 3.565339555e-02 0 3.570371689e-02 0 3.570372689e-02 1 3.570406206e-02 1
+ 3.570407206e-02 0 3.575439325e-02 0 3.575440325e-02 1 3.575473804e-02 1 3.575474804e-02 0 3.580506954e-02 0 3.580507954e-02 1 3.580541433e-02 1
+ 3.580542433e-02 0 3.585574540e-02 0 3.585575540e-02 1 3.585609083e-02 1 3.585610083e-02 0 3.589166867e-02 0 3.589167867e-02 1 3.589170116e-02 1
+ 3.589220116e-02 0 3.878366920e-02 0 3.878367920e-02 1 3.878401417e-02 1 3.878402417e-02 0 3.883434566e-02 0 3.883435566e-02 1 3.883469020e-02 1
+ 3.883470020e-02 0 3.888502166e-02 0 3.888503166e-02 1 3.888536668e-02 1 3.888537668e-02 0 3.893569790e-02 0 3.893570790e-02 1 3.893604277e-02 1
+ 3.893605277e-02 0 3.898637431e-02 0 3.898638431e-02 1 3.898671889e-02 1 3.898672889e-02 0 3.903705023e-02 0 3.903706023e-02 1 3.903739540e-02 1
+ 3.903740540e-02 0 3.908772659e-02 0 3.908773659e-02 1 3.908807138e-02 1 3.908808138e-02 0 3.913840288e-02 0 3.913841288e-02 1 3.913874767e-02 1
+ 3.913875767e-02 0 3.918907874e-02 0 3.918908874e-02 1 3.918942417e-02 1 3.918943417e-02 0 3.922500200e-02 0 3.922501200e-02 1 3.922503450e-02 1
+ 3.922553450e-02 0 4.211700253e-02 0 4.211701253e-02 1 4.211734750e-02 1 4.211735750e-02 0 4.216767899e-02 0 4.216768899e-02 1 4.216802353e-02 1
+ 4.216803353e-02 0 4.221835499e-02 0 4.221836499e-02 1 4.221870001e-02 1 4.221871001e-02 0 4.226903123e-02 0 4.226904123e-02 1 4.226937610e-02 1
+ 4.226938610e-02 0 4.231970764e-02 0 4.231971764e-02 1 4.232005222e-02 1 4.232006222e-02 0 4.237038357e-02 0 4.237039357e-02 1 4.237072873e-02 1
+ 4.237073873e-02 0 4.242105992e-02 0 4.242106992e-02 1 4.242140471e-02 1 4.242141471e-02 0 4.247173621e-02 0 4.247174621e-02 1 4.247208100e-02 1
+ 4.247209100e-02 0 4.252241207e-02 0 4.252242207e-02 1 4.252275750e-02 1 4.252276750e-02 0 4.255833533e-02 0 4.255834533e-02 1 4.255836784e-02 1
+ 4.255886784e-02 0 4.433333333e-02 0)
V_sSG4b1 8 s_sg4b1 0
XSG4b1 s_sg4b1 2 mbi_sg4b1 mf_sg4b1 mr_sg4b1 ia2_gap
V_mbi_sg4b1 mbi_sg4b1 0 PWL(0.000000000e+00 0 2.558335333e-03 0 2.558835333e-03 1 3.166668667e-03 1 3.167168667e-03 0 5.891668667e-03 0 5.892168667e-03 1 6.500002000e-03 1
+ 6.500502000e-03 0 9.225002000e-03 0 9.225502000e-03 1 9.833335333e-03 1 9.833835333e-03 0 1.255833533e-02 0 1.255883533e-02 1 1.316666867e-02 1
+ 1.316716867e-02 0 1.589166867e-02 0 1.589216867e-02 1 1.650000200e-02 1 1.650050200e-02 0 1.922500200e-02 0 1.922550200e-02 1 1.983333533e-02 1
+ 1.983383533e-02 0 2.255833533e-02 0 2.255883533e-02 1 2.316666867e-02 1 2.316716867e-02 0 2.589166867e-02 0 2.589216867e-02 1 2.650000200e-02 1
+ 2.650050200e-02 0 2.922500200e-02 0 2.922550200e-02 1 2.983333533e-02 1 2.983383533e-02 0 3.255833533e-02 0 3.255883533e-02 1 3.316666867e-02 1
+ 3.316716867e-02 0 3.589166867e-02 0 3.589216867e-02 1 3.650000200e-02 1 3.650050200e-02 0 3.922500200e-02 0 3.922550200e-02 1 3.983333533e-02 1
+ 3.983383533e-02 0 4.255833533e-02 0 4.255883533e-02 1 4.316666867e-02 1 4.316716867e-02 0 4.433333333e-02 0)
V_mf_sg4b1 mf_sg4b1 0 PWL(0.000000000e+00 0 4.433333333e-02 0)
V_mr_sg4b1 mr_sg4b1 0 PWL(0.000000000e+00 0 4.433333333e-02 0)
.ic v(1)=-100.0 v(2)=0.0 v(3)=0.0 v(4)=-100.0 v(7)=0.0 v(8)=0.0 v(n17)=0.0 v(n23)=0.0 v(q_c1)=-14.8 v(q_c2)=-14.8 v(q_cx3)=0 v(q_cx4)=0
.control
set filetype=binary
tran 1.00e-06 4.333333e-02 uic
write ia_raw/ia2_R1_SR_h_0_77_trec_1e_06_s_5_0_m_0_rt_None_br_a_it1.raw v(1) v(2) v(3) v(4) v(7) v(8) v(n17) v(n23) i(v_sbs3) i(v_sbs4) i(v_ssg1) i(v_ssg2) i(v_ssg3a1) i(v_ssg3b1) i(v_ssg4a1) i(v_ssg4b1) i(l_lx3) i(l_lx4)
.endc
.options reltol=1e-04 abstol=1e-9 vntol=1e-9 gmin=1e-14 maxstep=1.00e-06 method=trap itl4=200
.end
