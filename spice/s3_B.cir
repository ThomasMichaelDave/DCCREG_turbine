* S3-B: doubler + Lx + V_strike rectifying sparkgaps on rail-return + load
C1v 1 0 Q='(1.6e-11+2.64e-10*(0.5*(1+tanh(12.0*sin(6.283185e+03*time)))))*V(1)'
C2v 4 0 Q='(1.6e-11+2.64e-10*(0.5*(1+tanh(12.0*sin(6.283185e+03*time+3.14159265)))))*V(4)'
Cpar1 1 0 2e-11
Cpar2 2 0 2e-11
Cpar3 3 0 2e-11
Cpar4 4 0 2e-11
Ca 1 2 3.09e-10
Cb 3 4 3.09e-10
.model ND D(is=1e-9 n=0.005 rs=1e-3 cjo=0)
.model GAP SW(vt=3.0 vh=1.2 ron=2 roff=1G)
Lx1 2 m1 1e-4
Sg1 m1 g1 2 0 GAP
Dg1 g1 0 ND
Lx2 3 m2 1e-4
Sg2 m2 g2 3 0 GAP
Dg2 g2 0 ND
Dd3 1 3 ND
Dd4 4 2 ND
Rload 1 0 5e6
.ic v(1)=-1 v(2)=0 v(3)=0 v(4)=-1
.control
tran 1e-7 1.2e-2 uic
wrdata s3_B.dat v(1) v(4)
.endc
.options method=gear reltol=1e-4 abstol=1e-11 vntol=1e-8 gmin=1e-13 maxstep=1e-7
.end
