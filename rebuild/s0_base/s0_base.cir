* S0 base: de Queiroz Fig. 1, symmetrical unipolar generator -- generated by rebuild/s0_base/s0_base.py from TOPOLOGY
C1v 1 0 Q='(6.0000e-11+3.0000e-10*(0.5*(1+cos(1.25663706e+02*time))))*V(1)'
C2v 4 0 Q='(6.0000e-11+3.0000e-10*(0.5*(1-cos(1.25663706e+02*time))))*V(4)'
Ca 1 2 3.3000e-10
Cb 3 4 3.3000e-10
.model ND D(is=1e-12 n=0.005 rs=1e-3 cjo=0)
D1 0 2 ND
D2 0 3 ND
D3 3 1 ND
D4 2 4 ND
.ic v(1)=1.0 v(4)=1.0 v(2)=0 v(3)=0
.control
tran 1.2500e-05 8.000000e-01 uic
wrdata out.dat v(1) v(2) v(3) v(4)
.endc
.options reltol=1e-6 abstol=1e-15 vntol=1e-9 maxstep=1.2500e-05 method=gear
.end
